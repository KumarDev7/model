* Generated via PySpice Circuit object
.title FP8_MAC
* --- generic low-voltage CMOS (educational). Replace with a foundry BSIM4 ---
* --- card (.include 65nm_bulk.pm) for sign-off; W/L already in the M lines. -
.model NMOS NMOS (LEVEL=1 VTO=0.35  KP=300u GAMMA=0.40 PHI=0.90 LAMBDA=0.10
+                 CGSO=0.15n CGDO=0.15n CJ=1.0m CJSW=0.2n)
.model PMOS PMOS (LEVEL=1 VTO=-0.35 KP=90u  GAMMA=0.45 PHI=0.90 LAMBDA=0.12
+                 CGSO=0.15n CGDO=0.15n CJ=1.0m CJSW=0.2n)
VVDD VDD 0 1.0
MP37 nor4_33 A3_4 nu_34 VDD PMOS l=6.000000000000001e-08 w=4.0000000000000003e-07
MP38 nu_34 A4_5 nu_35 VDD PMOS l=6.000000000000001e-08 w=4.0000000000000003e-07
MP39 nu_35 A5_6 nu_36 VDD PMOS l=6.000000000000001e-08 w=4.0000000000000003e-07
MP40 nu_36 A6_7 VDD VDD PMOS l=6.000000000000001e-08 w=4.0000000000000003e-07
MN41 nor4_33 A3_4 0 0 NMOS l=6.000000000000001e-08 w=2.0000000000000002e-07
MN42 nor4_33 A4_5 0 0 NMOS l=6.000000000000001e-08 w=2.0000000000000002e-07
MN43 nor4_33 A5_6 0 0 NMOS l=6.000000000000001e-08 w=2.0000000000000002e-07
MN44 nor4_33 A6_7 0 0 NMOS l=6.000000000000001e-08 w=2.0000000000000002e-07
MP46 nand_45 A3_4 VDD VDD PMOS l=6.000000000000001e-08 w=4.0000000000000003e-07
MP47 nand_45 A4_5 VDD VDD PMOS l=6.000000000000001e-08 w=4.0000000000000003e-07
MN49 nand_45 A3_4 nd_48 0 NMOS l=6.000000000000001e-08 w=2.0000000000000002e-07
MN50 nd_48 A4_5 0 0 NMOS l=6.000000000000001e-08 w=2.0000000000000002e-07
MP52 inv_51 nand_45 VDD VDD PMOS l=6.000000000000001e-08 w=4.0000000000000003e-07
MN53 inv_51 nand_45 0 0 NMOS l=6.000000000000001e-08 w=2.0000000000000002e-07
MP55 nand_54 A5_6 VDD VDD PMOS l=6.000000000000001e-08 w=4.0000000000000003e-07
MP56 nand_54 A6_7 VDD VDD PMOS l=6.000000000000001e-08 w=4.0000000000000003e-07
MN58 nand_54 A5_6 nd_57 0 NMOS l=6.000000000000001e-08 w=2.0000000000000002e-07
MN59 nd_57 A6_7 0 0 NMOS l=6.000000000000001e-08 w=2.0000000000000002e-07
MP61 inv_60 nand_54 VDD VDD PMOS l=6.000000000000001e-08 w=4.0000000000000003e-07
MN62 inv_60 nand_54 0 0 NMOS l=6.000000000000001e-08 w=2.0000000000000002e-07
MP64 nand_63 inv_51 VDD VDD PMOS l=6.000000000000001e-08 w=4.0000000000000003e-07
MP65 nand_63 inv_60 VDD VDD PMOS l=6.000000000000001e-08 w=4.0000000000000003e-07
MN67 nand_63 inv_51 nd_66 0 NMOS l=6.000000000000001e-08 w=2.0000000000000002e-07
MN68 nd_66 inv_60 0 0 NMOS l=6.000000000000001e-08 w=2.0000000000000002e-07
MP70 inv_69 nand_63 VDD VDD PMOS l=6.000000000000001e-08 w=4.0000000000000003e-07
MN71 inv_69 nand_63 0 0 NMOS l=6.000000000000001e-08 w=2.0000000000000002e-07
MP73 nand_72 A0_1 VDD VDD PMOS l=6.000000000000001e-08 w=4.0000000000000003e-07
MP74 nand_72 A1_2 VDD VDD PMOS l=6.000000000000001e-08 w=4.0000000000000003e-07
MN76 nand_72 A0_1 nd_75 0 NMOS l=6.000000000000001e-08 w=2.0000000000000002e-07
MN77 nd_75 A1_2 0 0 NMOS l=6.000000000000001e-08 w=2.0000000000000002e-07
MP79 inv_78 nand_72 VDD VDD PMOS l=6.000000000000001e-08 w=4.0000000000000003e-07
MN80 inv_78 nand_72 0 0 NMOS l=6.000000000000001e-08 w=2.0000000000000002e-07
MP82 nand_81 inv_78 VDD VDD PMOS l=6.000000000000001e-08 w=4.0000000000000003e-07
MP83 nand_81 A2_3 VDD VDD PMOS l=6.000000000000001e-08 w=4.0000000000000003e-07
MN85 nand_81 inv_78 nd_84 0 NMOS l=6.000000000000001e-08 w=2.0000000000000002e-07
MN86 nd_84 A2_3 0 0 NMOS l=6.000000000000001e-08 w=2.0000000000000002e-07
MP88 inv_87 nand_81 VDD VDD PMOS l=6.000000000000001e-08 w=4.0000000000000003e-07
MN89 inv_87 nand_81 0 0 NMOS l=6.000000000000001e-08 w=2.0000000000000002e-07
MP91 nand_90 inv_69 VDD VDD PMOS l=6.000000000000001e-08 w=4.0000000000000003e-07
MP92 nand_90 inv_87 VDD VDD PMOS l=6.000000000000001e-08 w=4.0000000000000003e-07
MN94 nand_90 inv_69 nd_93 0 NMOS l=6.000000000000001e-08 w=2.0000000000000002e-07
MN95 nd_93 inv_87 0 0 NMOS l=6.000000000000001e-08 w=2.0000000000000002e-07
MP97 inv_96 nand_90 VDD VDD PMOS l=6.000000000000001e-08 w=4.0000000000000003e-07
MN98 inv_96 nand_90 0 0 NMOS l=6.000000000000001e-08 w=2.0000000000000002e-07
MP101 nor_99 nor4_33 nu_100 VDD PMOS l=6.000000000000001e-08 w=4.0000000000000003e-07
MP102 nu_100 inv_96 VDD VDD PMOS l=6.000000000000001e-08 w=4.0000000000000003e-07
MN103 nor_99 nor4_33 0 0 NMOS l=6.000000000000001e-08 w=2.0000000000000002e-07
MN104 nor_99 inv_96 0 0 NMOS l=6.000000000000001e-08 w=2.0000000000000002e-07
MP106 inv_105 nor_99 VDD VDD PMOS l=6.000000000000001e-08 w=4.0000000000000003e-07
MN107 inv_105 nor_99 0 0 NMOS l=6.000000000000001e-08 w=2.0000000000000002e-07
MP112 nor4_108 B3_12 nu_109 VDD PMOS l=6.000000000000001e-08 w=4.0000000000000003e-07
MP113 nu_109 B4_13 nu_110 VDD PMOS l=6.000000000000001e-08 w=4.0000000000000003e-07
MP114 nu_110 B5_14 nu_111 VDD PMOS l=6.000000000000001e-08 w=4.0000000000000003e-07
MP115 nu_111 B6_15 VDD VDD PMOS l=6.000000000000001e-08 w=4.0000000000000003e-07
MN116 nor4_108 B3_12 0 0 NMOS l=6.000000000000001e-08 w=2.0000000000000002e-07
MN117 nor4_108 B4_13 0 0 NMOS l=6.000000000000001e-08 w=2.0000000000000002e-07
MN118 nor4_108 B5_14 0 0 NMOS l=6.000000000000001e-08 w=2.0000000000000002e-07
MN119 nor4_108 B6_15 0 0 NMOS l=6.000000000000001e-08 w=2.0000000000000002e-07
MP121 nand_120 B3_12 VDD VDD PMOS l=6.000000000000001e-08 w=4.0000000000000003e-07
MP122 nand_120 B4_13 VDD VDD PMOS l=6.000000000000001e-08 w=4.0000000000000003e-07
MN124 nand_120 B3_12 nd_123 0 NMOS l=6.000000000000001e-08 w=2.0000000000000002e-07
MN125 nd_123 B4_13 0 0 NMOS l=6.000000000000001e-08 w=2.0000000000000002e-07
MP127 inv_126 nand_120 VDD VDD PMOS l=6.000000000000001e-08 w=4.0000000000000003e-07
MN128 inv_126 nand_120 0 0 NMOS l=6.000000000000001e-08 w=2.0000000000000002e-07
MP130 nand_129 B5_14 VDD VDD PMOS l=6.000000000000001e-08 w=4.0000000000000003e-07
MP131 nand_129 B6_15 VDD VDD PMOS l=6.000000000000001e-08 w=4.0000000000000003e-07
MN133 nand_129 B5_14 nd_132 0 NMOS l=6.000000000000001e-08 w=2.0000000000000002e-07
MN134 nd_132 B6_15 0 0 NMOS l=6.000000000000001e-08 w=2.0000000000000002e-07
MP136 inv_135 nand_129 VDD VDD PMOS l=6.000000000000001e-08 w=4.0000000000000003e-07
MN137 inv_135 nand_129 0 0 NMOS l=6.000000000000001e-08 w=2.0000000000000002e-07
MP139 nand_138 inv_126 VDD VDD PMOS l=6.000000000000001e-08 w=4.0000000000000003e-07
MP140 nand_138 inv_135 VDD VDD PMOS l=6.000000000000001e-08 w=4.0000000000000003e-07
MN142 nand_138 inv_126 nd_141 0 NMOS l=6.000000000000001e-08 w=2.0000000000000002e-07
MN143 nd_141 inv_135 0 0 NMOS l=6.000000000000001e-08 w=2.0000000000000002e-07
MP145 inv_144 nand_138 VDD VDD PMOS l=6.000000000000001e-08 w=4.0000000000000003e-07
MN146 inv_144 nand_138 0 0 NMOS l=6.000000000000001e-08 w=2.0000000000000002e-07
MP148 nand_147 B0_9 VDD VDD PMOS l=6.000000000000001e-08 w=4.0000000000000003e-07
MP149 nand_147 B1_10 VDD VDD PMOS l=6.000000000000001e-08 w=4.0000000000000003e-07
MN151 nand_147 B0_9 nd_150 0 NMOS l=6.000000000000001e-08 w=2.0000000000000002e-07
MN152 nd_150 B1_10 0 0 NMOS l=6.000000000000001e-08 w=2.0000000000000002e-07
MP154 inv_153 nand_147 VDD VDD PMOS l=6.000000000000001e-08 w=4.0000000000000003e-07
MN155 inv_153 nand_147 0 0 NMOS l=6.000000000000001e-08 w=2.0000000000000002e-07
MP157 nand_156 inv_153 VDD VDD PMOS l=6.000000000000001e-08 w=4.0000000000000003e-07
MP158 nand_156 B2_11 VDD VDD PMOS l=6.000000000000001e-08 w=4.0000000000000003e-07
MN160 nand_156 inv_153 nd_159 0 NMOS l=6.000000000000001e-08 w=2.0000000000000002e-07
MN161 nd_159 B2_11 0 0 NMOS l=6.000000000000001e-08 w=2.0000000000000002e-07
MP163 inv_162 nand_156 VDD VDD PMOS l=6.000000000000001e-08 w=4.0000000000000003e-07
MN164 inv_162 nand_156 0 0 NMOS l=6.000000000000001e-08 w=2.0000000000000002e-07
MP166 nand_165 inv_144 VDD VDD PMOS l=6.000000000000001e-08 w=4.0000000000000003e-07
MP167 nand_165 inv_162 VDD VDD PMOS l=6.000000000000001e-08 w=4.0000000000000003e-07
MN169 nand_165 inv_144 nd_168 0 NMOS l=6.000000000000001e-08 w=2.0000000000000002e-07
MN170 nd_168 inv_162 0 0 NMOS l=6.000000000000001e-08 w=2.0000000000000002e-07
MP172 inv_171 nand_165 VDD VDD PMOS l=6.000000000000001e-08 w=4.0000000000000003e-07
MN173 inv_171 nand_165 0 0 NMOS l=6.000000000000001e-08 w=2.0000000000000002e-07
MP176 nor_174 nor4_108 nu_175 VDD PMOS l=6.000000000000001e-08 w=4.0000000000000003e-07
MP177 nu_175 inv_171 VDD VDD PMOS l=6.000000000000001e-08 w=4.0000000000000003e-07
MN178 nor_174 nor4_108 0 0 NMOS l=6.000000000000001e-08 w=2.0000000000000002e-07
MN179 nor_174 inv_171 0 0 NMOS l=6.000000000000001e-08 w=2.0000000000000002e-07
MP181 inv_180 nor_174 VDD VDD PMOS l=6.000000000000001e-08 w=4.0000000000000003e-07
MN182 inv_180 nor_174 0 0 NMOS l=6.000000000000001e-08 w=2.0000000000000002e-07
MP185 nor_183 inv_105 nu_184 VDD PMOS l=6.000000000000001e-08 w=4.0000000000000003e-07
MP186 nu_184 inv_180 VDD VDD PMOS l=6.000000000000001e-08 w=4.0000000000000003e-07
MN187 nor_183 inv_105 0 0 NMOS l=6.000000000000001e-08 w=2.0000000000000002e-07
MN188 nor_183 inv_180 0 0 NMOS l=6.000000000000001e-08 w=2.0000000000000002e-07
MP190 inv_189 nor_183 VDD VDD PMOS l=6.000000000000001e-08 w=4.0000000000000003e-07
MN191 inv_189 nor_183 0 0 NMOS l=6.000000000000001e-08 w=2.0000000000000002e-07
MP194 inv_193 A7_8 VDD VDD PMOS l=6.000000000000001e-08 w=4.0000000000000003e-07
MN195 inv_193 A7_8 0 0 NMOS l=6.000000000000001e-08 w=2.0000000000000002e-07
MP197 inv_196 B7_16 VDD VDD PMOS l=6.000000000000001e-08 w=4.0000000000000003e-07
MN198 inv_196 B7_16 0 0 NMOS l=6.000000000000001e-08 w=2.0000000000000002e-07
MN199 A7_8 inv_196 xor_192 0 NMOS l=6.000000000000001e-08 w=2.0000000000000002e-07
MP200 A7_8 B7_16 xor_192 VDD PMOS l=6.000000000000001e-08 w=4.0000000000000003e-07
MN201 inv_193 B7_16 xor_192 0 NMOS l=6.000000000000001e-08 w=2.0000000000000002e-07
MP202 inv_193 inv_196 xor_192 VDD PMOS l=6.000000000000001e-08 w=4.0000000000000003e-07
MP204 nand_203 A0_1 VDD VDD PMOS l=6.000000000000001e-08 w=4.0000000000000003e-07
MP205 nand_203 B0_9 VDD VDD PMOS l=6.000000000000001e-08 w=4.0000000000000003e-07
MN207 nand_203 A0_1 nd_206 0 NMOS l=6.000000000000001e-08 w=2.0000000000000002e-07
MN208 nd_206 B0_9 0 0 NMOS l=6.000000000000001e-08 w=2.0000000000000002e-07
MP210 inv_209 nand_203 VDD VDD PMOS l=6.000000000000001e-08 w=4.0000000000000003e-07
MN211 inv_209 nand_203 0 0 NMOS l=6.000000000000001e-08 w=2.0000000000000002e-07
MP213 nand_212 A0_1 VDD VDD PMOS l=6.000000000000001e-08 w=4.0000000000000003e-07
MP214 nand_212 B1_10 VDD VDD PMOS l=6.000000000000001e-08 w=4.0000000000000003e-07
MN216 nand_212 A0_1 nd_215 0 NMOS l=6.000000000000001e-08 w=2.0000000000000002e-07
MN217 nd_215 B1_10 0 0 NMOS l=6.000000000000001e-08 w=2.0000000000000002e-07
MP219 inv_218 nand_212 VDD VDD PMOS l=6.000000000000001e-08 w=4.0000000000000003e-07
MN220 inv_218 nand_212 0 0 NMOS l=6.000000000000001e-08 w=2.0000000000000002e-07
MP222 nand_221 A0_1 VDD VDD PMOS l=6.000000000000001e-08 w=4.0000000000000003e-07
MP223 nand_221 B2_11 VDD VDD PMOS l=6.000000000000001e-08 w=4.0000000000000003e-07
MN225 nand_221 A0_1 nd_224 0 NMOS l=6.000000000000001e-08 w=2.0000000000000002e-07
MN226 nd_224 B2_11 0 0 NMOS l=6.000000000000001e-08 w=2.0000000000000002e-07
MP228 inv_227 nand_221 VDD VDD PMOS l=6.000000000000001e-08 w=4.0000000000000003e-07
MN229 inv_227 nand_221 0 0 NMOS l=6.000000000000001e-08 w=2.0000000000000002e-07
MP231 nand_230 A1_2 VDD VDD PMOS l=6.000000000000001e-08 w=4.0000000000000003e-07
MP232 nand_230 B0_9 VDD VDD PMOS l=6.000000000000001e-08 w=4.0000000000000003e-07
MN234 nand_230 A1_2 nd_233 0 NMOS l=6.000000000000001e-08 w=2.0000000000000002e-07
MN235 nd_233 B0_9 0 0 NMOS l=6.000000000000001e-08 w=2.0000000000000002e-07
MP237 inv_236 nand_230 VDD VDD PMOS l=6.000000000000001e-08 w=4.0000000000000003e-07
MN238 inv_236 nand_230 0 0 NMOS l=6.000000000000001e-08 w=2.0000000000000002e-07
MP240 nand_239 A1_2 VDD VDD PMOS l=6.000000000000001e-08 w=4.0000000000000003e-07
MP241 nand_239 B1_10 VDD VDD PMOS l=6.000000000000001e-08 w=4.0000000000000003e-07
MN243 nand_239 A1_2 nd_242 0 NMOS l=6.000000000000001e-08 w=2.0000000000000002e-07
MN244 nd_242 B1_10 0 0 NMOS l=6.000000000000001e-08 w=2.0000000000000002e-07
MP246 inv_245 nand_239 VDD VDD PMOS l=6.000000000000001e-08 w=4.0000000000000003e-07
MN247 inv_245 nand_239 0 0 NMOS l=6.000000000000001e-08 w=2.0000000000000002e-07
MP249 nand_248 A1_2 VDD VDD PMOS l=6.000000000000001e-08 w=4.0000000000000003e-07
MP250 nand_248 B2_11 VDD VDD PMOS l=6.000000000000001e-08 w=4.0000000000000003e-07
MN252 nand_248 A1_2 nd_251 0 NMOS l=6.000000000000001e-08 w=2.0000000000000002e-07
MN253 nd_251 B2_11 0 0 NMOS l=6.000000000000001e-08 w=2.0000000000000002e-07
MP255 inv_254 nand_248 VDD VDD PMOS l=6.000000000000001e-08 w=4.0000000000000003e-07
MN256 inv_254 nand_248 0 0 NMOS l=6.000000000000001e-08 w=2.0000000000000002e-07
MP258 nand_257 A2_3 VDD VDD PMOS l=6.000000000000001e-08 w=4.0000000000000003e-07
MP259 nand_257 B0_9 VDD VDD PMOS l=6.000000000000001e-08 w=4.0000000000000003e-07
MN261 nand_257 A2_3 nd_260 0 NMOS l=6.000000000000001e-08 w=2.0000000000000002e-07
MN262 nd_260 B0_9 0 0 NMOS l=6.000000000000001e-08 w=2.0000000000000002e-07
MP264 inv_263 nand_257 VDD VDD PMOS l=6.000000000000001e-08 w=4.0000000000000003e-07
MN265 inv_263 nand_257 0 0 NMOS l=6.000000000000001e-08 w=2.0000000000000002e-07
MP267 nand_266 A2_3 VDD VDD PMOS l=6.000000000000001e-08 w=4.0000000000000003e-07
MP268 nand_266 B1_10 VDD VDD PMOS l=6.000000000000001e-08 w=4.0000000000000003e-07
MN270 nand_266 A2_3 nd_269 0 NMOS l=6.000000000000001e-08 w=2.0000000000000002e-07
MN271 nd_269 B1_10 0 0 NMOS l=6.000000000000001e-08 w=2.0000000000000002e-07
MP273 inv_272 nand_266 VDD VDD PMOS l=6.000000000000001e-08 w=4.0000000000000003e-07
MN274 inv_272 nand_266 0 0 NMOS l=6.000000000000001e-08 w=2.0000000000000002e-07
MP276 nand_275 A2_3 VDD VDD PMOS l=6.000000000000001e-08 w=4.0000000000000003e-07
MP277 nand_275 B2_11 VDD VDD PMOS l=6.000000000000001e-08 w=4.0000000000000003e-07
MN279 nand_275 A2_3 nd_278 0 NMOS l=6.000000000000001e-08 w=2.0000000000000002e-07
MN280 nd_278 B2_11 0 0 NMOS l=6.000000000000001e-08 w=2.0000000000000002e-07
MP282 inv_281 nand_275 VDD VDD PMOS l=6.000000000000001e-08 w=4.0000000000000003e-07
MN283 inv_281 nand_275 0 0 NMOS l=6.000000000000001e-08 w=2.0000000000000002e-07
MP285 inv_284 inv_218 VDD VDD PMOS l=6.000000000000001e-08 w=4.0000000000000003e-07
MN286 inv_284 inv_218 0 0 NMOS l=6.000000000000001e-08 w=2.0000000000000002e-07
MP288 inv_287 inv_236 VDD VDD PMOS l=6.000000000000001e-08 w=4.0000000000000003e-07
MN289 inv_287 inv_236 0 0 NMOS l=6.000000000000001e-08 w=2.0000000000000002e-07
MN291 inv_218 inv_287 xor_290 0 NMOS l=6.000000000000001e-08 w=2.0000000000000002e-07
MP292 inv_218 inv_236 xor_290 VDD PMOS l=6.000000000000001e-08 w=4.0000000000000003e-07
MN293 inv_284 inv_236 xor_290 0 NMOS l=6.000000000000001e-08 w=2.0000000000000002e-07
MP294 inv_284 inv_287 xor_290 VDD PMOS l=6.000000000000001e-08 w=4.0000000000000003e-07
MP296 nand_295 inv_218 VDD VDD PMOS l=6.000000000000001e-08 w=4.0000000000000003e-07
MP297 nand_295 inv_236 VDD VDD PMOS l=6.000000000000001e-08 w=4.0000000000000003e-07
MN299 nand_295 inv_218 nd_298 0 NMOS l=6.000000000000001e-08 w=2.0000000000000002e-07
MN300 nd_298 inv_236 0 0 NMOS l=6.000000000000001e-08 w=2.0000000000000002e-07
MP302 inv_301 nand_295 VDD VDD PMOS l=6.000000000000001e-08 w=4.0000000000000003e-07
MN303 inv_301 nand_295 0 0 NMOS l=6.000000000000001e-08 w=2.0000000000000002e-07
MP305 inv_304 inv_227 VDD VDD PMOS l=6.000000000000001e-08 w=4.0000000000000003e-07
MN306 inv_304 inv_227 0 0 NMOS l=6.000000000000001e-08 w=2.0000000000000002e-07
MP308 inv_307 inv_245 VDD VDD PMOS l=6.000000000000001e-08 w=4.0000000000000003e-07
MN309 inv_307 inv_245 0 0 NMOS l=6.000000000000001e-08 w=2.0000000000000002e-07
MN311 inv_227 inv_307 xor_310 0 NMOS l=6.000000000000001e-08 w=2.0000000000000002e-07
MP312 inv_227 inv_245 xor_310 VDD PMOS l=6.000000000000001e-08 w=4.0000000000000003e-07
MN313 inv_304 inv_245 xor_310 0 NMOS l=6.000000000000001e-08 w=2.0000000000000002e-07
MP314 inv_304 inv_307 xor_310 VDD PMOS l=6.000000000000001e-08 w=4.0000000000000003e-07
MP316 inv_315 xor_310 VDD VDD PMOS l=6.000000000000001e-08 w=4.0000000000000003e-07
MN317 inv_315 xor_310 0 0 NMOS l=6.000000000000001e-08 w=2.0000000000000002e-07
MP319 inv_318 inv_263 VDD VDD PMOS l=6.000000000000001e-08 w=4.0000000000000003e-07
MN320 inv_318 inv_263 0 0 NMOS l=6.000000000000001e-08 w=2.0000000000000002e-07
MN322 xor_310 inv_318 xor_321 0 NMOS l=6.000000000000001e-08 w=2.0000000000000002e-07
MP323 xor_310 inv_263 xor_321 VDD PMOS l=6.000000000000001e-08 w=4.0000000000000003e-07
MN324 inv_315 inv_263 xor_321 0 NMOS l=6.000000000000001e-08 w=2.0000000000000002e-07
MP325 inv_315 inv_318 xor_321 VDD PMOS l=6.000000000000001e-08 w=4.0000000000000003e-07
MN327 inv_263 xor_310 cout_326 0 NMOS l=6.000000000000001e-08 w=2.0000000000000002e-07
MP328 inv_263 inv_315 cout_326 VDD PMOS l=6.000000000000001e-08 w=4.0000000000000003e-07
MN329 inv_227 inv_315 cout_326 0 NMOS l=6.000000000000001e-08 w=2.0000000000000002e-07
MP330 inv_227 xor_310 cout_326 VDD PMOS l=6.000000000000001e-08 w=4.0000000000000003e-07
MP332 inv_331 A0_1 VDD VDD PMOS l=6.000000000000001e-08 w=4.0000000000000003e-07
MN333 inv_331 A0_1 0 0 NMOS l=6.000000000000001e-08 w=2.0000000000000002e-07
MP335 inv_334 inv_254 VDD VDD PMOS l=6.000000000000001e-08 w=4.0000000000000003e-07
MN336 inv_334 inv_254 0 0 NMOS l=6.000000000000001e-08 w=2.0000000000000002e-07
MN338 A0_1 inv_334 xor_337 0 NMOS l=6.000000000000001e-08 w=2.0000000000000002e-07
MP339 A0_1 inv_254 xor_337 VDD PMOS l=6.000000000000001e-08 w=4.0000000000000003e-07
MN340 inv_331 inv_254 xor_337 0 NMOS l=6.000000000000001e-08 w=2.0000000000000002e-07
MP341 inv_331 inv_334 xor_337 VDD PMOS l=6.000000000000001e-08 w=4.0000000000000003e-07
MP343 inv_342 xor_337 VDD VDD PMOS l=6.000000000000001e-08 w=4.0000000000000003e-07
MN344 inv_342 xor_337 0 0 NMOS l=6.000000000000001e-08 w=2.0000000000000002e-07
MP346 inv_345 inv_272 VDD VDD PMOS l=6.000000000000001e-08 w=4.0000000000000003e-07
MN347 inv_345 inv_272 0 0 NMOS l=6.000000000000001e-08 w=2.0000000000000002e-07
MN349 xor_337 inv_345 xor_348 0 NMOS l=6.000000000000001e-08 w=2.0000000000000002e-07
MP350 xor_337 inv_272 xor_348 VDD PMOS l=6.000000000000001e-08 w=4.0000000000000003e-07
MN351 inv_342 inv_272 xor_348 0 NMOS l=6.000000000000001e-08 w=2.0000000000000002e-07
MP352 inv_342 inv_345 xor_348 VDD PMOS l=6.000000000000001e-08 w=4.0000000000000003e-07
MN354 inv_272 xor_337 cout_353 0 NMOS l=6.000000000000001e-08 w=2.0000000000000002e-07
MP355 inv_272 inv_342 cout_353 VDD PMOS l=6.000000000000001e-08 w=4.0000000000000003e-07
MN356 A0_1 inv_342 cout_353 0 NMOS l=6.000000000000001e-08 w=2.0000000000000002e-07
MP357 A0_1 xor_337 cout_353 VDD PMOS l=6.000000000000001e-08 w=4.0000000000000003e-07
MP359 inv_358 A1_2 VDD VDD PMOS l=6.000000000000001e-08 w=4.0000000000000003e-07
MN360 inv_358 A1_2 0 0 NMOS l=6.000000000000001e-08 w=2.0000000000000002e-07
MP362 inv_361 inv_281 VDD VDD PMOS l=6.000000000000001e-08 w=4.0000000000000003e-07
MN363 inv_361 inv_281 0 0 NMOS l=6.000000000000001e-08 w=2.0000000000000002e-07
MN365 A1_2 inv_361 xor_364 0 NMOS l=6.000000000000001e-08 w=2.0000000000000002e-07
MP366 A1_2 inv_281 xor_364 VDD PMOS l=6.000000000000001e-08 w=4.0000000000000003e-07
MN367 inv_358 inv_281 xor_364 0 NMOS l=6.000000000000001e-08 w=2.0000000000000002e-07
MP368 inv_358 inv_361 xor_364 VDD PMOS l=6.000000000000001e-08 w=4.0000000000000003e-07
MP370 inv_369 xor_364 VDD VDD PMOS l=6.000000000000001e-08 w=4.0000000000000003e-07
MN371 inv_369 xor_364 0 0 NMOS l=6.000000000000001e-08 w=2.0000000000000002e-07
MP373 inv_372 B1_10 VDD VDD PMOS l=6.000000000000001e-08 w=4.0000000000000003e-07
MN374 inv_372 B1_10 0 0 NMOS l=6.000000000000001e-08 w=2.0000000000000002e-07
MN376 xor_364 inv_372 xor_375 0 NMOS l=6.000000000000001e-08 w=2.0000000000000002e-07
MP377 xor_364 B1_10 xor_375 VDD PMOS l=6.000000000000001e-08 w=4.0000000000000003e-07
MN378 inv_369 B1_10 xor_375 0 NMOS l=6.000000000000001e-08 w=2.0000000000000002e-07
MP379 inv_369 inv_372 xor_375 VDD PMOS l=6.000000000000001e-08 w=4.0000000000000003e-07
MN381 B1_10 xor_364 cout_380 0 NMOS l=6.000000000000001e-08 w=2.0000000000000002e-07
MP382 B1_10 inv_369 cout_380 VDD PMOS l=6.000000000000001e-08 w=4.0000000000000003e-07
MN383 A1_2 inv_369 cout_380 0 NMOS l=6.000000000000001e-08 w=2.0000000000000002e-07
MP384 A1_2 xor_364 cout_380 VDD PMOS l=6.000000000000001e-08 w=4.0000000000000003e-07
MP386 inv_385 A2_3 VDD VDD PMOS l=6.000000000000001e-08 w=4.0000000000000003e-07
MN387 inv_385 A2_3 0 0 NMOS l=6.000000000000001e-08 w=2.0000000000000002e-07
MP389 inv_388 B2_11 VDD VDD PMOS l=6.000000000000001e-08 w=4.0000000000000003e-07
MN390 inv_388 B2_11 0 0 NMOS l=6.000000000000001e-08 w=2.0000000000000002e-07
MN392 A2_3 inv_388 xor_391 0 NMOS l=6.000000000000001e-08 w=2.0000000000000002e-07
MP393 A2_3 B2_11 xor_391 VDD PMOS l=6.000000000000001e-08 w=4.0000000000000003e-07
MN394 inv_385 B2_11 xor_391 0 NMOS l=6.000000000000001e-08 w=2.0000000000000002e-07
MP395 inv_385 inv_388 xor_391 VDD PMOS l=6.000000000000001e-08 w=4.0000000000000003e-07
MP397 nand_396 A2_3 VDD VDD PMOS l=6.000000000000001e-08 w=4.0000000000000003e-07
MP398 nand_396 B2_11 VDD VDD PMOS l=6.000000000000001e-08 w=4.0000000000000003e-07
MN400 nand_396 A2_3 nd_399 0 NMOS l=6.000000000000001e-08 w=2.0000000000000002e-07
MN401 nd_399 B2_11 0 0 NMOS l=6.000000000000001e-08 w=2.0000000000000002e-07
MP403 inv_402 nand_396 VDD VDD PMOS l=6.000000000000001e-08 w=4.0000000000000003e-07
MN404 inv_402 nand_396 0 0 NMOS l=6.000000000000001e-08 w=2.0000000000000002e-07
MP406 inv_405 inv_301 VDD VDD PMOS l=6.000000000000001e-08 w=4.0000000000000003e-07
MN407 inv_405 inv_301 0 0 NMOS l=6.000000000000001e-08 w=2.0000000000000002e-07
MP409 inv_408 xor_321 VDD VDD PMOS l=6.000000000000001e-08 w=4.0000000000000003e-07
MN410 inv_408 xor_321 0 0 NMOS l=6.000000000000001e-08 w=2.0000000000000002e-07
MN412 inv_301 inv_408 xor_411 0 NMOS l=6.000000000000001e-08 w=2.0000000000000002e-07
MP413 inv_301 xor_321 xor_411 VDD PMOS l=6.000000000000001e-08 w=4.0000000000000003e-07
MN414 inv_405 xor_321 xor_411 0 NMOS l=6.000000000000001e-08 w=2.0000000000000002e-07
MP415 inv_405 inv_408 xor_411 VDD PMOS l=6.000000000000001e-08 w=4.0000000000000003e-07
MP417 nand_416 inv_301 VDD VDD PMOS l=6.000000000000001e-08 w=4.0000000000000003e-07
MP418 nand_416 xor_321 VDD VDD PMOS l=6.000000000000001e-08 w=4.0000000000000003e-07
MN420 nand_416 inv_301 nd_419 0 NMOS l=6.000000000000001e-08 w=2.0000000000000002e-07
MN421 nd_419 xor_321 0 0 NMOS l=6.000000000000001e-08 w=2.0000000000000002e-07
MP423 inv_422 nand_416 VDD VDD PMOS l=6.000000000000001e-08 w=4.0000000000000003e-07
MN424 inv_422 nand_416 0 0 NMOS l=6.000000000000001e-08 w=2.0000000000000002e-07
MP426 inv_425 cout_326 VDD VDD PMOS l=6.000000000000001e-08 w=4.0000000000000003e-07
MN427 inv_425 cout_326 0 0 NMOS l=6.000000000000001e-08 w=2.0000000000000002e-07
MP429 inv_428 xor_348 VDD VDD PMOS l=6.000000000000001e-08 w=4.0000000000000003e-07
MN430 inv_428 xor_348 0 0 NMOS l=6.000000000000001e-08 w=2.0000000000000002e-07
MN432 cout_326 inv_428 xor_431 0 NMOS l=6.000000000000001e-08 w=2.0000000000000002e-07
MP433 cout_326 xor_348 xor_431 VDD PMOS l=6.000000000000001e-08 w=4.0000000000000003e-07
MN434 inv_425 xor_348 xor_431 0 NMOS l=6.000000000000001e-08 w=2.0000000000000002e-07
MP435 inv_425 inv_428 xor_431 VDD PMOS l=6.000000000000001e-08 w=4.0000000000000003e-07
MP437 inv_436 xor_431 VDD VDD PMOS l=6.000000000000001e-08 w=4.0000000000000003e-07
MN438 inv_436 xor_431 0 0 NMOS l=6.000000000000001e-08 w=2.0000000000000002e-07
MP440 inv_439 B0_9 VDD VDD PMOS l=6.000000000000001e-08 w=4.0000000000000003e-07
MN441 inv_439 B0_9 0 0 NMOS l=6.000000000000001e-08 w=2.0000000000000002e-07
MN443 xor_431 inv_439 xor_442 0 NMOS l=6.000000000000001e-08 w=2.0000000000000002e-07
MP444 xor_431 B0_9 xor_442 VDD PMOS l=6.000000000000001e-08 w=4.0000000000000003e-07
MN445 inv_436 B0_9 xor_442 0 NMOS l=6.000000000000001e-08 w=2.0000000000000002e-07
MP446 inv_436 inv_439 xor_442 VDD PMOS l=6.000000000000001e-08 w=4.0000000000000003e-07
MN448 B0_9 xor_431 cout_447 0 NMOS l=6.000000000000001e-08 w=2.0000000000000002e-07
MP449 B0_9 inv_436 cout_447 VDD PMOS l=6.000000000000001e-08 w=4.0000000000000003e-07
MN450 cout_326 inv_436 cout_447 0 NMOS l=6.000000000000001e-08 w=2.0000000000000002e-07
MP451 cout_326 xor_431 cout_447 VDD PMOS l=6.000000000000001e-08 w=4.0000000000000003e-07
MP453 inv_452 cout_353 VDD VDD PMOS l=6.000000000000001e-08 w=4.0000000000000003e-07
MN454 inv_452 cout_353 0 0 NMOS l=6.000000000000001e-08 w=2.0000000000000002e-07
MP456 inv_455 xor_375 VDD VDD PMOS l=6.000000000000001e-08 w=4.0000000000000003e-07
MN457 inv_455 xor_375 0 0 NMOS l=6.000000000000001e-08 w=2.0000000000000002e-07
MN459 cout_353 inv_455 xor_458 0 NMOS l=6.000000000000001e-08 w=2.0000000000000002e-07
MP460 cout_353 xor_375 xor_458 VDD PMOS l=6.000000000000001e-08 w=4.0000000000000003e-07
MN461 inv_452 xor_375 xor_458 0 NMOS l=6.000000000000001e-08 w=2.0000000000000002e-07
MP462 inv_452 inv_455 xor_458 VDD PMOS l=6.000000000000001e-08 w=4.0000000000000003e-07
MP464 nand_463 cout_353 VDD VDD PMOS l=6.000000000000001e-08 w=4.0000000000000003e-07
MP465 nand_463 xor_375 VDD VDD PMOS l=6.000000000000001e-08 w=4.0000000000000003e-07
MN467 nand_463 cout_353 nd_466 0 NMOS l=6.000000000000001e-08 w=2.0000000000000002e-07
MN468 nd_466 xor_375 0 0 NMOS l=6.000000000000001e-08 w=2.0000000000000002e-07
MP470 inv_469 nand_463 VDD VDD PMOS l=6.000000000000001e-08 w=4.0000000000000003e-07
MN471 inv_469 nand_463 0 0 NMOS l=6.000000000000001e-08 w=2.0000000000000002e-07
MP473 inv_472 cout_380 VDD VDD PMOS l=6.000000000000001e-08 w=4.0000000000000003e-07
MN474 inv_472 cout_380 0 0 NMOS l=6.000000000000001e-08 w=2.0000000000000002e-07
MP476 inv_475 xor_391 VDD VDD PMOS l=6.000000000000001e-08 w=4.0000000000000003e-07
MN477 inv_475 xor_391 0 0 NMOS l=6.000000000000001e-08 w=2.0000000000000002e-07
MN479 cout_380 inv_475 xor_478 0 NMOS l=6.000000000000001e-08 w=2.0000000000000002e-07
MP480 cout_380 xor_391 xor_478 VDD PMOS l=6.000000000000001e-08 w=4.0000000000000003e-07
MN481 inv_472 xor_391 xor_478 0 NMOS l=6.000000000000001e-08 w=2.0000000000000002e-07
MP482 inv_472 inv_475 xor_478 VDD PMOS l=6.000000000000001e-08 w=4.0000000000000003e-07
MP484 nand_483 cout_380 VDD VDD PMOS l=6.000000000000001e-08 w=4.0000000000000003e-07
MP485 nand_483 xor_391 VDD VDD PMOS l=6.000000000000001e-08 w=4.0000000000000003e-07
MN487 nand_483 cout_380 nd_486 0 NMOS l=6.000000000000001e-08 w=2.0000000000000002e-07
MN488 nd_486 xor_391 0 0 NMOS l=6.000000000000001e-08 w=2.0000000000000002e-07
MP490 inv_489 nand_483 VDD VDD PMOS l=6.000000000000001e-08 w=4.0000000000000003e-07
MN491 inv_489 nand_483 0 0 NMOS l=6.000000000000001e-08 w=2.0000000000000002e-07
MP493 inv_492 inv_402 VDD VDD PMOS l=6.000000000000001e-08 w=4.0000000000000003e-07
MN494 inv_492 inv_402 0 0 NMOS l=6.000000000000001e-08 w=2.0000000000000002e-07
MP496 inv_495 inv_422 VDD VDD PMOS l=6.000000000000001e-08 w=4.0000000000000003e-07
MN497 inv_495 inv_422 0 0 NMOS l=6.000000000000001e-08 w=2.0000000000000002e-07
MP499 inv_498 xor_442 VDD VDD PMOS l=6.000000000000001e-08 w=4.0000000000000003e-07
MN500 inv_498 xor_442 0 0 NMOS l=6.000000000000001e-08 w=2.0000000000000002e-07
MN502 inv_422 inv_498 xor_501 0 NMOS l=6.000000000000001e-08 w=2.0000000000000002e-07
MP503 inv_422 xor_442 xor_501 VDD PMOS l=6.000000000000001e-08 w=4.0000000000000003e-07
MN504 inv_495 xor_442 xor_501 0 NMOS l=6.000000000000001e-08 w=2.0000000000000002e-07
MP505 inv_495 inv_498 xor_501 VDD PMOS l=6.000000000000001e-08 w=4.0000000000000003e-07
MP507 nand_506 inv_422 VDD VDD PMOS l=6.000000000000001e-08 w=4.0000000000000003e-07
MP508 nand_506 xor_442 VDD VDD PMOS l=6.000000000000001e-08 w=4.0000000000000003e-07
MN510 nand_506 inv_422 nd_509 0 NMOS l=6.000000000000001e-08 w=2.0000000000000002e-07
MN511 nd_509 xor_442 0 0 NMOS l=6.000000000000001e-08 w=2.0000000000000002e-07
MP513 inv_512 nand_506 VDD VDD PMOS l=6.000000000000001e-08 w=4.0000000000000003e-07
MN514 inv_512 nand_506 0 0 NMOS l=6.000000000000001e-08 w=2.0000000000000002e-07
MP516 inv_515 cout_447 VDD VDD PMOS l=6.000000000000001e-08 w=4.0000000000000003e-07
MN517 inv_515 cout_447 0 0 NMOS l=6.000000000000001e-08 w=2.0000000000000002e-07
MP519 inv_518 xor_458 VDD VDD PMOS l=6.000000000000001e-08 w=4.0000000000000003e-07
MN520 inv_518 xor_458 0 0 NMOS l=6.000000000000001e-08 w=2.0000000000000002e-07
MN522 cout_447 inv_518 xor_521 0 NMOS l=6.000000000000001e-08 w=2.0000000000000002e-07
MP523 cout_447 xor_458 xor_521 VDD PMOS l=6.000000000000001e-08 w=4.0000000000000003e-07
MN524 inv_515 xor_458 xor_521 0 NMOS l=6.000000000000001e-08 w=2.0000000000000002e-07
MP525 inv_515 inv_518 xor_521 VDD PMOS l=6.000000000000001e-08 w=4.0000000000000003e-07
MP527 inv_526 xor_521 VDD VDD PMOS l=6.000000000000001e-08 w=4.0000000000000003e-07
MN528 inv_526 xor_521 0 0 NMOS l=6.000000000000001e-08 w=2.0000000000000002e-07
MP530 inv_529 inv_512 VDD VDD PMOS l=6.000000000000001e-08 w=4.0000000000000003e-07
MN531 inv_529 inv_512 0 0 NMOS l=6.000000000000001e-08 w=2.0000000000000002e-07
MN533 xor_521 inv_529 xor_532 0 NMOS l=6.000000000000001e-08 w=2.0000000000000002e-07
MP534 xor_521 inv_512 xor_532 VDD PMOS l=6.000000000000001e-08 w=4.0000000000000003e-07
MN535 inv_526 inv_512 xor_532 0 NMOS l=6.000000000000001e-08 w=2.0000000000000002e-07
MP536 inv_526 inv_529 xor_532 VDD PMOS l=6.000000000000001e-08 w=4.0000000000000003e-07
MN538 inv_512 xor_521 cout_537 0 NMOS l=6.000000000000001e-08 w=2.0000000000000002e-07
MP539 inv_512 inv_526 cout_537 VDD PMOS l=6.000000000000001e-08 w=4.0000000000000003e-07
MN540 cout_447 inv_526 cout_537 0 NMOS l=6.000000000000001e-08 w=2.0000000000000002e-07
MP541 cout_447 xor_521 cout_537 VDD PMOS l=6.000000000000001e-08 w=4.0000000000000003e-07
MP543 inv_542 cout_537 VDD VDD PMOS l=6.000000000000001e-08 w=4.0000000000000003e-07
MN544 inv_542 cout_537 0 0 NMOS l=6.000000000000001e-08 w=2.0000000000000002e-07
MP546 inv_545 inv_542 VDD VDD PMOS l=6.000000000000001e-08 w=4.0000000000000003e-07
MN547 inv_545 inv_542 0 0 NMOS l=6.000000000000001e-08 w=2.0000000000000002e-07
MP549 inv_548 inv_469 VDD VDD PMOS l=6.000000000000001e-08 w=4.0000000000000003e-07
MN550 inv_548 inv_469 0 0 NMOS l=6.000000000000001e-08 w=2.0000000000000002e-07
MP552 inv_551 xor_478 VDD VDD PMOS l=6.000000000000001e-08 w=4.0000000000000003e-07
MN553 inv_551 xor_478 0 0 NMOS l=6.000000000000001e-08 w=2.0000000000000002e-07
MN555 inv_469 inv_551 xor_554 0 NMOS l=6.000000000000001e-08 w=2.0000000000000002e-07
MP556 inv_469 xor_478 xor_554 VDD PMOS l=6.000000000000001e-08 w=4.0000000000000003e-07
MN557 inv_548 xor_478 xor_554 0 NMOS l=6.000000000000001e-08 w=2.0000000000000002e-07
MP558 inv_548 inv_551 xor_554 VDD PMOS l=6.000000000000001e-08 w=4.0000000000000003e-07
MP560 inv_559 xor_554 VDD VDD PMOS l=6.000000000000001e-08 w=4.0000000000000003e-07
MN561 inv_559 xor_554 0 0 NMOS l=6.000000000000001e-08 w=2.0000000000000002e-07
MP563 inv_562 inv_545 VDD VDD PMOS l=6.000000000000001e-08 w=4.0000000000000003e-07
MN564 inv_562 inv_545 0 0 NMOS l=6.000000000000001e-08 w=2.0000000000000002e-07
MN566 xor_554 inv_562 xor_565 0 NMOS l=6.000000000000001e-08 w=2.0000000000000002e-07
MP567 xor_554 inv_545 xor_565 VDD PMOS l=6.000000000000001e-08 w=4.0000000000000003e-07
MN568 inv_559 inv_545 xor_565 0 NMOS l=6.000000000000001e-08 w=2.0000000000000002e-07
MP569 inv_559 inv_562 xor_565 VDD PMOS l=6.000000000000001e-08 w=4.0000000000000003e-07
MN571 inv_545 xor_554 cout_570 0 NMOS l=6.000000000000001e-08 w=2.0000000000000002e-07
MP572 inv_545 inv_559 cout_570 VDD PMOS l=6.000000000000001e-08 w=4.0000000000000003e-07
MN573 inv_469 inv_559 cout_570 0 NMOS l=6.000000000000001e-08 w=2.0000000000000002e-07
MP574 inv_469 xor_554 cout_570 VDD PMOS l=6.000000000000001e-08 w=4.0000000000000003e-07
MP576 inv_575 inv_489 VDD VDD PMOS l=6.000000000000001e-08 w=4.0000000000000003e-07
MN577 inv_575 inv_489 0 0 NMOS l=6.000000000000001e-08 w=2.0000000000000002e-07
MP579 inv_578 inv_492 VDD VDD PMOS l=6.000000000000001e-08 w=4.0000000000000003e-07
MN580 inv_578 inv_492 0 0 NMOS l=6.000000000000001e-08 w=2.0000000000000002e-07
MN582 inv_489 inv_578 xor_581 0 NMOS l=6.000000000000001e-08 w=2.0000000000000002e-07
MP583 inv_489 inv_492 xor_581 VDD PMOS l=6.000000000000001e-08 w=4.0000000000000003e-07
MN584 inv_575 inv_492 xor_581 0 NMOS l=6.000000000000001e-08 w=2.0000000000000002e-07
MP585 inv_575 inv_578 xor_581 VDD PMOS l=6.000000000000001e-08 w=4.0000000000000003e-07
MP587 inv_586 xor_581 VDD VDD PMOS l=6.000000000000001e-08 w=4.0000000000000003e-07
MN588 inv_586 xor_581 0 0 NMOS l=6.000000000000001e-08 w=2.0000000000000002e-07
MP590 inv_589 cout_570 VDD VDD PMOS l=6.000000000000001e-08 w=4.0000000000000003e-07
MN591 inv_589 cout_570 0 0 NMOS l=6.000000000000001e-08 w=2.0000000000000002e-07
MN593 xor_581 inv_589 xor_592 0 NMOS l=6.000000000000001e-08 w=2.0000000000000002e-07
MP594 xor_581 cout_570 xor_592 VDD PMOS l=6.000000000000001e-08 w=4.0000000000000003e-07
MN595 inv_586 cout_570 xor_592 0 NMOS l=6.000000000000001e-08 w=2.0000000000000002e-07
MP596 inv_586 inv_589 xor_592 VDD PMOS l=6.000000000000001e-08 w=4.0000000000000003e-07
MN598 cout_570 xor_581 cout_597 0 NMOS l=6.000000000000001e-08 w=2.0000000000000002e-07
MP599 cout_570 inv_586 cout_597 VDD PMOS l=6.000000000000001e-08 w=4.0000000000000003e-07
MN600 inv_489 inv_586 cout_597 0 NMOS l=6.000000000000001e-08 w=2.0000000000000002e-07
MP601 inv_489 xor_581 cout_597 VDD PMOS l=6.000000000000001e-08 w=4.0000000000000003e-07
MP603 inv_602 inv_402 VDD VDD PMOS l=6.000000000000001e-08 w=4.0000000000000003e-07
MN604 inv_602 inv_402 0 0 NMOS l=6.000000000000001e-08 w=2.0000000000000002e-07
MP606 inv_605 cout_597 VDD VDD PMOS l=6.000000000000001e-08 w=4.0000000000000003e-07
MN607 inv_605 cout_597 0 0 NMOS l=6.000000000000001e-08 w=2.0000000000000002e-07
MN609 inv_402 inv_605 xor_608 0 NMOS l=6.000000000000001e-08 w=2.0000000000000002e-07
MP610 inv_402 cout_597 xor_608 VDD PMOS l=6.000000000000001e-08 w=4.0000000000000003e-07
MN611 inv_602 cout_597 xor_608 0 NMOS l=6.000000000000001e-08 w=2.0000000000000002e-07
MP612 inv_602 inv_605 xor_608 VDD PMOS l=6.000000000000001e-08 w=4.0000000000000003e-07
MP614 nand_613 inv_402 VDD VDD PMOS l=6.000000000000001e-08 w=4.0000000000000003e-07
MP615 nand_613 cout_597 VDD VDD PMOS l=6.000000000000001e-08 w=4.0000000000000003e-07
MN617 nand_613 inv_402 nd_616 0 NMOS l=6.000000000000001e-08 w=2.0000000000000002e-07
MN618 nd_616 cout_597 0 0 NMOS l=6.000000000000001e-08 w=2.0000000000000002e-07
MP620 inv_619 nand_613 VDD VDD PMOS l=6.000000000000001e-08 w=4.0000000000000003e-07
MN621 inv_619 nand_613 0 0 NMOS l=6.000000000000001e-08 w=2.0000000000000002e-07
MP623 inv_622 A3_4 VDD VDD PMOS l=6.000000000000001e-08 w=4.0000000000000003e-07
MN624 inv_622 A3_4 0 0 NMOS l=6.000000000000001e-08 w=2.0000000000000002e-07
MP626 inv_625 B3_12 VDD VDD PMOS l=6.000000000000001e-08 w=4.0000000000000003e-07
MN627 inv_625 B3_12 0 0 NMOS l=6.000000000000001e-08 w=2.0000000000000002e-07
MN629 A3_4 inv_625 xor_628 0 NMOS l=6.000000000000001e-08 w=2.0000000000000002e-07
MP630 A3_4 B3_12 xor_628 VDD PMOS l=6.000000000000001e-08 w=4.0000000000000003e-07
MN631 inv_622 B3_12 xor_628 0 NMOS l=6.000000000000001e-08 w=2.0000000000000002e-07
MP632 inv_622 inv_625 xor_628 VDD PMOS l=6.000000000000001e-08 w=4.0000000000000003e-07
MP634 nand_633 A3_4 VDD VDD PMOS l=6.000000000000001e-08 w=4.0000000000000003e-07
MP635 nand_633 B3_12 VDD VDD PMOS l=6.000000000000001e-08 w=4.0000000000000003e-07
MN637 nand_633 A3_4 nd_636 0 NMOS l=6.000000000000001e-08 w=2.0000000000000002e-07
MN638 nd_636 B3_12 0 0 NMOS l=6.000000000000001e-08 w=2.0000000000000002e-07
MP640 inv_639 nand_633 VDD VDD PMOS l=6.000000000000001e-08 w=4.0000000000000003e-07
MN641 inv_639 nand_633 0 0 NMOS l=6.000000000000001e-08 w=2.0000000000000002e-07
MP643 inv_642 A4_5 VDD VDD PMOS l=6.000000000000001e-08 w=4.0000000000000003e-07
MN644 inv_642 A4_5 0 0 NMOS l=6.000000000000001e-08 w=2.0000000000000002e-07
MP646 inv_645 B4_13 VDD VDD PMOS l=6.000000000000001e-08 w=4.0000000000000003e-07
MN647 inv_645 B4_13 0 0 NMOS l=6.000000000000001e-08 w=2.0000000000000002e-07
MN649 A4_5 inv_645 xor_648 0 NMOS l=6.000000000000001e-08 w=2.0000000000000002e-07
MP650 A4_5 B4_13 xor_648 VDD PMOS l=6.000000000000001e-08 w=4.0000000000000003e-07
MN651 inv_642 B4_13 xor_648 0 NMOS l=6.000000000000001e-08 w=2.0000000000000002e-07
MP652 inv_642 inv_645 xor_648 VDD PMOS l=6.000000000000001e-08 w=4.0000000000000003e-07
MP654 inv_653 xor_648 VDD VDD PMOS l=6.000000000000001e-08 w=4.0000000000000003e-07
MN655 inv_653 xor_648 0 0 NMOS l=6.000000000000001e-08 w=2.0000000000000002e-07
MP657 inv_656 inv_639 VDD VDD PMOS l=6.000000000000001e-08 w=4.0000000000000003e-07
MN658 inv_656 inv_639 0 0 NMOS l=6.000000000000001e-08 w=2.0000000000000002e-07
MN660 xor_648 inv_656 xor_659 0 NMOS l=6.000000000000001e-08 w=2.0000000000000002e-07
MP661 xor_648 inv_639 xor_659 VDD PMOS l=6.000000000000001e-08 w=4.0000000000000003e-07
MN662 inv_653 inv_639 xor_659 0 NMOS l=6.000000000000001e-08 w=2.0000000000000002e-07
MP663 inv_653 inv_656 xor_659 VDD PMOS l=6.000000000000001e-08 w=4.0000000000000003e-07
MN665 inv_639 xor_648 cout_664 0 NMOS l=6.000000000000001e-08 w=2.0000000000000002e-07
MP666 inv_639 inv_653 cout_664 VDD PMOS l=6.000000000000001e-08 w=4.0000000000000003e-07
MN667 A4_5 inv_653 cout_664 0 NMOS l=6.000000000000001e-08 w=2.0000000000000002e-07
MP668 A4_5 xor_648 cout_664 VDD PMOS l=6.000000000000001e-08 w=4.0000000000000003e-07
MP670 inv_669 A5_6 VDD VDD PMOS l=6.000000000000001e-08 w=4.0000000000000003e-07
MN671 inv_669 A5_6 0 0 NMOS l=6.000000000000001e-08 w=2.0000000000000002e-07
MP673 inv_672 B5_14 VDD VDD PMOS l=6.000000000000001e-08 w=4.0000000000000003e-07
MN674 inv_672 B5_14 0 0 NMOS l=6.000000000000001e-08 w=2.0000000000000002e-07
MN676 A5_6 inv_672 xor_675 0 NMOS l=6.000000000000001e-08 w=2.0000000000000002e-07
MP677 A5_6 B5_14 xor_675 VDD PMOS l=6.000000000000001e-08 w=4.0000000000000003e-07
MN678 inv_669 B5_14 xor_675 0 NMOS l=6.000000000000001e-08 w=2.0000000000000002e-07
MP679 inv_669 inv_672 xor_675 VDD PMOS l=6.000000000000001e-08 w=4.0000000000000003e-07
MP681 inv_680 xor_675 VDD VDD PMOS l=6.000000000000001e-08 w=4.0000000000000003e-07
MN682 inv_680 xor_675 0 0 NMOS l=6.000000000000001e-08 w=2.0000000000000002e-07
MP684 inv_683 cout_664 VDD VDD PMOS l=6.000000000000001e-08 w=4.0000000000000003e-07
MN685 inv_683 cout_664 0 0 NMOS l=6.000000000000001e-08 w=2.0000000000000002e-07
MN687 xor_675 inv_683 xor_686 0 NMOS l=6.000000000000001e-08 w=2.0000000000000002e-07
MP688 xor_675 cout_664 xor_686 VDD PMOS l=6.000000000000001e-08 w=4.0000000000000003e-07
MN689 inv_680 cout_664 xor_686 0 NMOS l=6.000000000000001e-08 w=2.0000000000000002e-07
MP690 inv_680 inv_683 xor_686 VDD PMOS l=6.000000000000001e-08 w=4.0000000000000003e-07
MN692 cout_664 xor_675 cout_691 0 NMOS l=6.000000000000001e-08 w=2.0000000000000002e-07
MP693 cout_664 inv_680 cout_691 VDD PMOS l=6.000000000000001e-08 w=4.0000000000000003e-07
MN694 A5_6 inv_680 cout_691 0 NMOS l=6.000000000000001e-08 w=2.0000000000000002e-07
MP695 A5_6 xor_675 cout_691 VDD PMOS l=6.000000000000001e-08 w=4.0000000000000003e-07
MP697 inv_696 A6_7 VDD VDD PMOS l=6.000000000000001e-08 w=4.0000000000000003e-07
MN698 inv_696 A6_7 0 0 NMOS l=6.000000000000001e-08 w=2.0000000000000002e-07
MP700 inv_699 B6_15 VDD VDD PMOS l=6.000000000000001e-08 w=4.0000000000000003e-07
MN701 inv_699 B6_15 0 0 NMOS l=6.000000000000001e-08 w=2.0000000000000002e-07
MN703 A6_7 inv_699 xor_702 0 NMOS l=6.000000000000001e-08 w=2.0000000000000002e-07
MP704 A6_7 B6_15 xor_702 VDD PMOS l=6.000000000000001e-08 w=4.0000000000000003e-07
MN705 inv_696 B6_15 xor_702 0 NMOS l=6.000000000000001e-08 w=2.0000000000000002e-07
MP706 inv_696 inv_699 xor_702 VDD PMOS l=6.000000000000001e-08 w=4.0000000000000003e-07
MP708 inv_707 xor_702 VDD VDD PMOS l=6.000000000000001e-08 w=4.0000000000000003e-07
MN709 inv_707 xor_702 0 0 NMOS l=6.000000000000001e-08 w=2.0000000000000002e-07
MP711 inv_710 cout_691 VDD VDD PMOS l=6.000000000000001e-08 w=4.0000000000000003e-07
MN712 inv_710 cout_691 0 0 NMOS l=6.000000000000001e-08 w=2.0000000000000002e-07
MN714 xor_702 inv_710 xor_713 0 NMOS l=6.000000000000001e-08 w=2.0000000000000002e-07
MP715 xor_702 cout_691 xor_713 VDD PMOS l=6.000000000000001e-08 w=4.0000000000000003e-07
MN716 inv_707 cout_691 xor_713 0 NMOS l=6.000000000000001e-08 w=2.0000000000000002e-07
MP717 inv_707 inv_710 xor_713 VDD PMOS l=6.000000000000001e-08 w=4.0000000000000003e-07
MN719 cout_691 xor_702 cout_718 0 NMOS l=6.000000000000001e-08 w=2.0000000000000002e-07
MP720 cout_691 inv_707 cout_718 VDD PMOS l=6.000000000000001e-08 w=4.0000000000000003e-07
MN721 A6_7 inv_707 cout_718 0 NMOS l=6.000000000000001e-08 w=2.0000000000000002e-07
MP722 A6_7 xor_702 cout_718 VDD PMOS l=6.000000000000001e-08 w=4.0000000000000003e-07
MP724 inv_723 xor_713 VDD VDD PMOS l=6.000000000000001e-08 w=4.0000000000000003e-07
MN725 inv_723 xor_713 0 0 NMOS l=6.000000000000001e-08 w=2.0000000000000002e-07
MP727 inv_726 cout_718 VDD VDD PMOS l=6.000000000000001e-08 w=4.0000000000000003e-07
MN728 inv_726 cout_718 0 0 NMOS l=6.000000000000001e-08 w=2.0000000000000002e-07
MP730 inv_729 xor_713 VDD VDD PMOS l=6.000000000000001e-08 w=4.0000000000000003e-07
MN731 inv_729 xor_713 0 0 NMOS l=6.000000000000001e-08 w=2.0000000000000002e-07
MN733 inv_726 inv_729 xnor_732 0 NMOS l=6.000000000000001e-08 w=2.0000000000000002e-07
MP734 inv_726 xor_713 xnor_732 VDD PMOS l=6.000000000000001e-08 w=4.0000000000000003e-07
MN735 cout_718 xor_713 xnor_732 0 NMOS l=6.000000000000001e-08 w=2.0000000000000002e-07
MP736 cout_718 inv_729 xnor_732 VDD PMOS l=6.000000000000001e-08 w=4.0000000000000003e-07
MP739 nor_737 cout_718 nu_738 VDD PMOS l=6.000000000000001e-08 w=4.0000000000000003e-07
MP740 nu_738 xor_713 VDD VDD PMOS l=6.000000000000001e-08 w=4.0000000000000003e-07
MN741 nor_737 cout_718 0 0 NMOS l=6.000000000000001e-08 w=2.0000000000000002e-07
MN742 nor_737 xor_713 0 0 NMOS l=6.000000000000001e-08 w=2.0000000000000002e-07
MP744 inv_743 nor_737 VDD VDD PMOS l=6.000000000000001e-08 w=4.0000000000000003e-07
MN745 inv_743 nor_737 0 0 NMOS l=6.000000000000001e-08 w=2.0000000000000002e-07
MP747 inv_746 inv_743 VDD VDD PMOS l=6.000000000000001e-08 w=4.0000000000000003e-07
MN748 inv_746 inv_743 0 0 NMOS l=6.000000000000001e-08 w=2.0000000000000002e-07
MP750 inv_749 xor_659 VDD VDD PMOS l=6.000000000000001e-08 w=4.0000000000000003e-07
MN751 inv_749 xor_659 0 0 NMOS l=6.000000000000001e-08 w=2.0000000000000002e-07
MP753 inv_752 xor_686 VDD VDD PMOS l=6.000000000000001e-08 w=4.0000000000000003e-07
MN754 inv_752 xor_686 0 0 NMOS l=6.000000000000001e-08 w=2.0000000000000002e-07
MP756 inv_755 xor_659 VDD VDD PMOS l=6.000000000000001e-08 w=4.0000000000000003e-07
MN757 inv_755 xor_659 0 0 NMOS l=6.000000000000001e-08 w=2.0000000000000002e-07
MN759 xor_686 inv_755 xor_758 0 NMOS l=6.000000000000001e-08 w=2.0000000000000002e-07
MP760 xor_686 xor_659 xor_758 VDD PMOS l=6.000000000000001e-08 w=4.0000000000000003e-07
MN761 inv_752 xor_659 xor_758 0 NMOS l=6.000000000000001e-08 w=2.0000000000000002e-07
MP762 inv_752 inv_755 xor_758 VDD PMOS l=6.000000000000001e-08 w=4.0000000000000003e-07
MP764 nand_763 xor_686 VDD VDD PMOS l=6.000000000000001e-08 w=4.0000000000000003e-07
MP765 nand_763 xor_659 VDD VDD PMOS l=6.000000000000001e-08 w=4.0000000000000003e-07
MN767 nand_763 xor_686 nd_766 0 NMOS l=6.000000000000001e-08 w=2.0000000000000002e-07
MN768 nd_766 xor_659 0 0 NMOS l=6.000000000000001e-08 w=2.0000000000000002e-07
MP770 inv_769 nand_763 VDD VDD PMOS l=6.000000000000001e-08 w=4.0000000000000003e-07
MN771 inv_769 nand_763 0 0 NMOS l=6.000000000000001e-08 w=2.0000000000000002e-07
MP773 inv_772 xor_713 VDD VDD PMOS l=6.000000000000001e-08 w=4.0000000000000003e-07
MN774 inv_772 xor_713 0 0 NMOS l=6.000000000000001e-08 w=2.0000000000000002e-07
MP776 inv_775 inv_769 VDD VDD PMOS l=6.000000000000001e-08 w=4.0000000000000003e-07
MN777 inv_775 inv_769 0 0 NMOS l=6.000000000000001e-08 w=2.0000000000000002e-07
MN779 inv_772 inv_775 xnor_778 0 NMOS l=6.000000000000001e-08 w=2.0000000000000002e-07
MP780 inv_772 inv_769 xnor_778 VDD PMOS l=6.000000000000001e-08 w=4.0000000000000003e-07
MN781 xor_713 inv_769 xnor_778 0 NMOS l=6.000000000000001e-08 w=2.0000000000000002e-07
MP782 xor_713 inv_775 xnor_778 VDD PMOS l=6.000000000000001e-08 w=4.0000000000000003e-07
MP785 nor_783 xor_713 nu_784 VDD PMOS l=6.000000000000001e-08 w=4.0000000000000003e-07
MP786 nu_784 inv_769 VDD VDD PMOS l=6.000000000000001e-08 w=4.0000000000000003e-07
MN787 nor_783 xor_713 0 0 NMOS l=6.000000000000001e-08 w=2.0000000000000002e-07
MN788 nor_783 inv_769 0 0 NMOS l=6.000000000000001e-08 w=2.0000000000000002e-07
MP790 inv_789 nor_783 VDD VDD PMOS l=6.000000000000001e-08 w=4.0000000000000003e-07
MN791 inv_789 nor_783 0 0 NMOS l=6.000000000000001e-08 w=2.0000000000000002e-07
MP793 inv_792 cout_718 VDD VDD PMOS l=6.000000000000001e-08 w=4.0000000000000003e-07
MN794 inv_792 cout_718 0 0 NMOS l=6.000000000000001e-08 w=2.0000000000000002e-07
MP796 inv_795 inv_789 VDD VDD PMOS l=6.000000000000001e-08 w=4.0000000000000003e-07
MN797 inv_795 inv_789 0 0 NMOS l=6.000000000000001e-08 w=2.0000000000000002e-07
MN799 cout_718 inv_795 xor_798 0 NMOS l=6.000000000000001e-08 w=2.0000000000000002e-07
MP800 cout_718 inv_789 xor_798 VDD PMOS l=6.000000000000001e-08 w=4.0000000000000003e-07
MN801 inv_792 inv_789 xor_798 0 NMOS l=6.000000000000001e-08 w=2.0000000000000002e-07
MP802 inv_792 inv_795 xor_798 VDD PMOS l=6.000000000000001e-08 w=4.0000000000000003e-07
MP804 nand_803 cout_718 VDD VDD PMOS l=6.000000000000001e-08 w=4.0000000000000003e-07
MP805 nand_803 inv_789 VDD VDD PMOS l=6.000000000000001e-08 w=4.0000000000000003e-07
MN807 nand_803 cout_718 nd_806 0 NMOS l=6.000000000000001e-08 w=2.0000000000000002e-07
MN808 nd_806 inv_789 0 0 NMOS l=6.000000000000001e-08 w=2.0000000000000002e-07
MP810 inv_809 nand_803 VDD VDD PMOS l=6.000000000000001e-08 w=4.0000000000000003e-07
MN811 inv_809 nand_803 0 0 NMOS l=6.000000000000001e-08 w=2.0000000000000002e-07
MP813 inv_812 inv_809 VDD VDD PMOS l=6.000000000000001e-08 w=4.0000000000000003e-07
MN814 inv_812 inv_809 0 0 NMOS l=6.000000000000001e-08 w=2.0000000000000002e-07
MP817 nor_815 inv_746 nu_816 VDD PMOS l=6.000000000000001e-08 w=4.0000000000000003e-07
MP818 nu_816 inv_189 VDD VDD PMOS l=6.000000000000001e-08 w=4.0000000000000003e-07
MN819 nor_815 inv_746 0 0 NMOS l=6.000000000000001e-08 w=2.0000000000000002e-07
MN820 nor_815 inv_189 0 0 NMOS l=6.000000000000001e-08 w=2.0000000000000002e-07
MP822 inv_821 nor_815 VDD VDD PMOS l=6.000000000000001e-08 w=4.0000000000000003e-07
MN823 inv_821 nor_815 0 0 NMOS l=6.000000000000001e-08 w=2.0000000000000002e-07
MP825 inv_824 inv_821 VDD VDD PMOS l=6.000000000000001e-08 w=4.0000000000000003e-07
MN826 inv_824 inv_821 0 0 NMOS l=6.000000000000001e-08 w=2.0000000000000002e-07
MP828 inv_827 inv_189 VDD VDD PMOS l=6.000000000000001e-08 w=4.0000000000000003e-07
MN829 inv_827 inv_189 0 0 NMOS l=6.000000000000001e-08 w=2.0000000000000002e-07
MP831 nand_830 inv_809 VDD VDD PMOS l=6.000000000000001e-08 w=4.0000000000000003e-07
MP832 nand_830 inv_827 VDD VDD PMOS l=6.000000000000001e-08 w=4.0000000000000003e-07
MN834 nand_830 inv_809 nd_833 0 NMOS l=6.000000000000001e-08 w=2.0000000000000002e-07
MN835 nd_833 inv_827 0 0 NMOS l=6.000000000000001e-08 w=2.0000000000000002e-07
MP837 inv_836 nand_830 VDD VDD PMOS l=6.000000000000001e-08 w=4.0000000000000003e-07
MN838 inv_836 nand_830 0 0 NMOS l=6.000000000000001e-08 w=2.0000000000000002e-07
MP840 nand_839 inv_209 VDD VDD PMOS l=6.000000000000001e-08 w=4.0000000000000003e-07
MP841 nand_839 inv_824 VDD VDD PMOS l=6.000000000000001e-08 w=4.0000000000000003e-07
MN843 nand_839 inv_209 nd_842 0 NMOS l=6.000000000000001e-08 w=2.0000000000000002e-07
MN844 nd_842 inv_824 0 0 NMOS l=6.000000000000001e-08 w=2.0000000000000002e-07
MP846 inv_845 nand_839 VDD VDD PMOS l=6.000000000000001e-08 w=4.0000000000000003e-07
MN847 inv_845 nand_839 0 0 NMOS l=6.000000000000001e-08 w=2.0000000000000002e-07
MP849 nand_848 xor_290 VDD VDD PMOS l=6.000000000000001e-08 w=4.0000000000000003e-07
MP850 nand_848 inv_824 VDD VDD PMOS l=6.000000000000001e-08 w=4.0000000000000003e-07
MN852 nand_848 xor_290 nd_851 0 NMOS l=6.000000000000001e-08 w=2.0000000000000002e-07
MN853 nd_851 inv_824 0 0 NMOS l=6.000000000000001e-08 w=2.0000000000000002e-07
MP855 inv_854 nand_848 VDD VDD PMOS l=6.000000000000001e-08 w=4.0000000000000003e-07
MN856 inv_854 nand_848 0 0 NMOS l=6.000000000000001e-08 w=2.0000000000000002e-07
MP858 nand_857 xor_411 VDD VDD PMOS l=6.000000000000001e-08 w=4.0000000000000003e-07
MP859 nand_857 inv_824 VDD VDD PMOS l=6.000000000000001e-08 w=4.0000000000000003e-07
MN861 nand_857 xor_411 nd_860 0 NMOS l=6.000000000000001e-08 w=2.0000000000000002e-07
MN862 nd_860 inv_824 0 0 NMOS l=6.000000000000001e-08 w=2.0000000000000002e-07
MP864 inv_863 nand_857 VDD VDD PMOS l=6.000000000000001e-08 w=4.0000000000000003e-07
MN865 inv_863 nand_857 0 0 NMOS l=6.000000000000001e-08 w=2.0000000000000002e-07
MP867 nand_866 xor_501 VDD VDD PMOS l=6.000000000000001e-08 w=4.0000000000000003e-07
MP868 nand_866 inv_824 VDD VDD PMOS l=6.000000000000001e-08 w=4.0000000000000003e-07
MN870 nand_866 xor_501 nd_869 0 NMOS l=6.000000000000001e-08 w=2.0000000000000002e-07
MN871 nd_869 inv_824 0 0 NMOS l=6.000000000000001e-08 w=2.0000000000000002e-07
MP873 inv_872 nand_866 VDD VDD PMOS l=6.000000000000001e-08 w=4.0000000000000003e-07
MN874 inv_872 nand_866 0 0 NMOS l=6.000000000000001e-08 w=2.0000000000000002e-07
MP876 nand_875 xor_532 VDD VDD PMOS l=6.000000000000001e-08 w=4.0000000000000003e-07
MP877 nand_875 inv_824 VDD VDD PMOS l=6.000000000000001e-08 w=4.0000000000000003e-07
MN879 nand_875 xor_532 nd_878 0 NMOS l=6.000000000000001e-08 w=2.0000000000000002e-07
MN880 nd_878 inv_824 0 0 NMOS l=6.000000000000001e-08 w=2.0000000000000002e-07
MP882 inv_881 nand_875 VDD VDD PMOS l=6.000000000000001e-08 w=4.0000000000000003e-07
MN883 inv_881 nand_875 0 0 NMOS l=6.000000000000001e-08 w=2.0000000000000002e-07
MP885 nand_884 xor_565 VDD VDD PMOS l=6.000000000000001e-08 w=4.0000000000000003e-07
MP886 nand_884 inv_824 VDD VDD PMOS l=6.000000000000001e-08 w=4.0000000000000003e-07
MN888 nand_884 xor_565 nd_887 0 NMOS l=6.000000000000001e-08 w=2.0000000000000002e-07
MN889 nd_887 inv_824 0 0 NMOS l=6.000000000000001e-08 w=2.0000000000000002e-07
MP891 inv_890 nand_884 VDD VDD PMOS l=6.000000000000001e-08 w=4.0000000000000003e-07
MN892 inv_890 nand_884 0 0 NMOS l=6.000000000000001e-08 w=2.0000000000000002e-07
MP894 nand_893 xor_592 VDD VDD PMOS l=6.000000000000001e-08 w=4.0000000000000003e-07
MP895 nand_893 inv_824 VDD VDD PMOS l=6.000000000000001e-08 w=4.0000000000000003e-07
MN897 nand_893 xor_592 nd_896 0 NMOS l=6.000000000000001e-08 w=2.0000000000000002e-07
MN898 nd_896 inv_824 0 0 NMOS l=6.000000000000001e-08 w=2.0000000000000002e-07
MP900 inv_899 nand_893 VDD VDD PMOS l=6.000000000000001e-08 w=4.0000000000000003e-07
MN901 inv_899 nand_893 0 0 NMOS l=6.000000000000001e-08 w=2.0000000000000002e-07
MP903 nand_902 xor_608 VDD VDD PMOS l=6.000000000000001e-08 w=4.0000000000000003e-07
MP904 nand_902 inv_824 VDD VDD PMOS l=6.000000000000001e-08 w=4.0000000000000003e-07
MN906 nand_902 xor_608 nd_905 0 NMOS l=6.000000000000001e-08 w=2.0000000000000002e-07
MN907 nd_905 inv_824 0 0 NMOS l=6.000000000000001e-08 w=2.0000000000000002e-07
MP909 inv_908 nand_902 VDD VDD PMOS l=6.000000000000001e-08 w=4.0000000000000003e-07
MN910 inv_908 nand_902 0 0 NMOS l=6.000000000000001e-08 w=2.0000000000000002e-07
MP912 inv_911 xor_628 VDD VDD PMOS l=6.000000000000001e-08 w=4.0000000000000003e-07
MN913 inv_911 xor_628 0 0 NMOS l=6.000000000000001e-08 w=2.0000000000000002e-07
MN915 inv_845 inv_911 mux_914 0 NMOS l=6.000000000000001e-08 w=2.0000000000000002e-07
MP916 inv_845 xor_628 mux_914 VDD PMOS l=6.000000000000001e-08 w=4.0000000000000003e-07
MN917 0 xor_628 mux_914 0 NMOS l=6.000000000000001e-08 w=2.0000000000000002e-07
MP918 0 inv_911 mux_914 VDD PMOS l=6.000000000000001e-08 w=4.0000000000000003e-07
MN920 inv_854 inv_911 mux_919 0 NMOS l=6.000000000000001e-08 w=2.0000000000000002e-07
MP921 inv_854 xor_628 mux_919 VDD PMOS l=6.000000000000001e-08 w=4.0000000000000003e-07
MN922 inv_845 xor_628 mux_919 0 NMOS l=6.000000000000001e-08 w=2.0000000000000002e-07
MP923 inv_845 inv_911 mux_919 VDD PMOS l=6.000000000000001e-08 w=4.0000000000000003e-07
MN925 inv_863 inv_911 mux_924 0 NMOS l=6.000000000000001e-08 w=2.0000000000000002e-07
MP926 inv_863 xor_628 mux_924 VDD PMOS l=6.000000000000001e-08 w=4.0000000000000003e-07
MN927 inv_854 xor_628 mux_924 0 NMOS l=6.000000000000001e-08 w=2.0000000000000002e-07
MP928 inv_854 inv_911 mux_924 VDD PMOS l=6.000000000000001e-08 w=4.0000000000000003e-07
MN930 inv_872 inv_911 mux_929 0 NMOS l=6.000000000000001e-08 w=2.0000000000000002e-07
MP931 inv_872 xor_628 mux_929 VDD PMOS l=6.000000000000001e-08 w=4.0000000000000003e-07
MN932 inv_863 xor_628 mux_929 0 NMOS l=6.000000000000001e-08 w=2.0000000000000002e-07
MP933 inv_863 inv_911 mux_929 VDD PMOS l=6.000000000000001e-08 w=4.0000000000000003e-07
MN935 inv_881 inv_911 mux_934 0 NMOS l=6.000000000000001e-08 w=2.0000000000000002e-07
MP936 inv_881 xor_628 mux_934 VDD PMOS l=6.000000000000001e-08 w=4.0000000000000003e-07
MN937 inv_872 xor_628 mux_934 0 NMOS l=6.000000000000001e-08 w=2.0000000000000002e-07
MP938 inv_872 inv_911 mux_934 VDD PMOS l=6.000000000000001e-08 w=4.0000000000000003e-07
MN940 inv_890 inv_911 mux_939 0 NMOS l=6.000000000000001e-08 w=2.0000000000000002e-07
MP941 inv_890 xor_628 mux_939 VDD PMOS l=6.000000000000001e-08 w=4.0000000000000003e-07
MN942 inv_881 xor_628 mux_939 0 NMOS l=6.000000000000001e-08 w=2.0000000000000002e-07
MP943 inv_881 inv_911 mux_939 VDD PMOS l=6.000000000000001e-08 w=4.0000000000000003e-07
MN945 inv_899 inv_911 mux_944 0 NMOS l=6.000000000000001e-08 w=2.0000000000000002e-07
MP946 inv_899 xor_628 mux_944 VDD PMOS l=6.000000000000001e-08 w=4.0000000000000003e-07
MN947 inv_890 xor_628 mux_944 0 NMOS l=6.000000000000001e-08 w=2.0000000000000002e-07
MP948 inv_890 inv_911 mux_944 VDD PMOS l=6.000000000000001e-08 w=4.0000000000000003e-07
MN950 inv_908 inv_911 mux_949 0 NMOS l=6.000000000000001e-08 w=2.0000000000000002e-07
MP951 inv_908 xor_628 mux_949 VDD PMOS l=6.000000000000001e-08 w=4.0000000000000003e-07
MN952 inv_899 xor_628 mux_949 0 NMOS l=6.000000000000001e-08 w=2.0000000000000002e-07
MP953 inv_899 inv_911 mux_949 VDD PMOS l=6.000000000000001e-08 w=4.0000000000000003e-07
MN955 0 inv_911 mux_954 0 NMOS l=6.000000000000001e-08 w=2.0000000000000002e-07
MP956 0 xor_628 mux_954 VDD PMOS l=6.000000000000001e-08 w=4.0000000000000003e-07
MN957 inv_908 xor_628 mux_954 0 NMOS l=6.000000000000001e-08 w=2.0000000000000002e-07
MP958 inv_908 inv_911 mux_954 VDD PMOS l=6.000000000000001e-08 w=4.0000000000000003e-07
MP960 inv_959 xor_659 VDD VDD PMOS l=6.000000000000001e-08 w=4.0000000000000003e-07
MN961 inv_959 xor_659 0 0 NMOS l=6.000000000000001e-08 w=2.0000000000000002e-07
MN963 mux_914 inv_959 mux_962 0 NMOS l=6.000000000000001e-08 w=2.0000000000000002e-07
MP964 mux_914 xor_659 mux_962 VDD PMOS l=6.000000000000001e-08 w=4.0000000000000003e-07
MN965 0 xor_659 mux_962 0 NMOS l=6.000000000000001e-08 w=2.0000000000000002e-07
MP966 0 inv_959 mux_962 VDD PMOS l=6.000000000000001e-08 w=4.0000000000000003e-07
MN968 mux_919 inv_959 mux_967 0 NMOS l=6.000000000000001e-08 w=2.0000000000000002e-07
MP969 mux_919 xor_659 mux_967 VDD PMOS l=6.000000000000001e-08 w=4.0000000000000003e-07
MN970 0 xor_659 mux_967 0 NMOS l=6.000000000000001e-08 w=2.0000000000000002e-07
MP971 0 inv_959 mux_967 VDD PMOS l=6.000000000000001e-08 w=4.0000000000000003e-07
MN973 mux_924 inv_959 mux_972 0 NMOS l=6.000000000000001e-08 w=2.0000000000000002e-07
MP974 mux_924 xor_659 mux_972 VDD PMOS l=6.000000000000001e-08 w=4.0000000000000003e-07
MN975 mux_914 xor_659 mux_972 0 NMOS l=6.000000000000001e-08 w=2.0000000000000002e-07
MP976 mux_914 inv_959 mux_972 VDD PMOS l=6.000000000000001e-08 w=4.0000000000000003e-07
MN978 mux_929 inv_959 mux_977 0 NMOS l=6.000000000000001e-08 w=2.0000000000000002e-07
MP979 mux_929 xor_659 mux_977 VDD PMOS l=6.000000000000001e-08 w=4.0000000000000003e-07
MN980 mux_919 xor_659 mux_977 0 NMOS l=6.000000000000001e-08 w=2.0000000000000002e-07
MP981 mux_919 inv_959 mux_977 VDD PMOS l=6.000000000000001e-08 w=4.0000000000000003e-07
MN983 mux_934 inv_959 mux_982 0 NMOS l=6.000000000000001e-08 w=2.0000000000000002e-07
MP984 mux_934 xor_659 mux_982 VDD PMOS l=6.000000000000001e-08 w=4.0000000000000003e-07
MN985 mux_924 xor_659 mux_982 0 NMOS l=6.000000000000001e-08 w=2.0000000000000002e-07
MP986 mux_924 inv_959 mux_982 VDD PMOS l=6.000000000000001e-08 w=4.0000000000000003e-07
MN988 mux_939 inv_959 mux_987 0 NMOS l=6.000000000000001e-08 w=2.0000000000000002e-07
MP989 mux_939 xor_659 mux_987 VDD PMOS l=6.000000000000001e-08 w=4.0000000000000003e-07
MN990 mux_929 xor_659 mux_987 0 NMOS l=6.000000000000001e-08 w=2.0000000000000002e-07
MP991 mux_929 inv_959 mux_987 VDD PMOS l=6.000000000000001e-08 w=4.0000000000000003e-07
MN993 mux_944 inv_959 mux_992 0 NMOS l=6.000000000000001e-08 w=2.0000000000000002e-07
MP994 mux_944 xor_659 mux_992 VDD PMOS l=6.000000000000001e-08 w=4.0000000000000003e-07
MN995 mux_934 xor_659 mux_992 0 NMOS l=6.000000000000001e-08 w=2.0000000000000002e-07
MP996 mux_934 inv_959 mux_992 VDD PMOS l=6.000000000000001e-08 w=4.0000000000000003e-07
MN998 mux_949 inv_959 mux_997 0 NMOS l=6.000000000000001e-08 w=2.0000000000000002e-07
MP999 mux_949 xor_659 mux_997 VDD PMOS l=6.000000000000001e-08 w=4.0000000000000003e-07
MN1000 mux_939 xor_659 mux_997 0 NMOS l=6.000000000000001e-08 w=2.0000000000000002e-07
MP1001 mux_939 inv_959 mux_997 VDD PMOS l=6.000000000000001e-08 w=4.0000000000000003e-07
MN1003 mux_954 inv_959 mux_1002 0 NMOS l=6.000000000000001e-08 w=2.0000000000000002e-07
MP1004 mux_954 xor_659 mux_1002 VDD PMOS l=6.000000000000001e-08 w=4.0000000000000003e-07
MN1005 mux_944 xor_659 mux_1002 0 NMOS l=6.000000000000001e-08 w=2.0000000000000002e-07
MP1006 mux_944 inv_959 mux_1002 VDD PMOS l=6.000000000000001e-08 w=4.0000000000000003e-07
MN1008 0 inv_959 mux_1007 0 NMOS l=6.000000000000001e-08 w=2.0000000000000002e-07
MP1009 0 xor_659 mux_1007 VDD PMOS l=6.000000000000001e-08 w=4.0000000000000003e-07
MN1010 mux_949 xor_659 mux_1007 0 NMOS l=6.000000000000001e-08 w=2.0000000000000002e-07
MP1011 mux_949 inv_959 mux_1007 VDD PMOS l=6.000000000000001e-08 w=4.0000000000000003e-07
MN1013 0 inv_959 mux_1012 0 NMOS l=6.000000000000001e-08 w=2.0000000000000002e-07
MP1014 0 xor_659 mux_1012 VDD PMOS l=6.000000000000001e-08 w=4.0000000000000003e-07
MN1015 mux_954 xor_659 mux_1012 0 NMOS l=6.000000000000001e-08 w=2.0000000000000002e-07
MP1016 mux_954 inv_959 mux_1012 VDD PMOS l=6.000000000000001e-08 w=4.0000000000000003e-07
MP1018 inv_1017 xor_686 VDD VDD PMOS l=6.000000000000001e-08 w=4.0000000000000003e-07
MN1019 inv_1017 xor_686 0 0 NMOS l=6.000000000000001e-08 w=2.0000000000000002e-07
MN1021 mux_962 inv_1017 mux_1020 0 NMOS l=6.000000000000001e-08 w=2.0000000000000002e-07
MP1022 mux_962 xor_686 mux_1020 VDD PMOS l=6.000000000000001e-08 w=4.0000000000000003e-07
MN1023 0 xor_686 mux_1020 0 NMOS l=6.000000000000001e-08 w=2.0000000000000002e-07
MP1024 0 inv_1017 mux_1020 VDD PMOS l=6.000000000000001e-08 w=4.0000000000000003e-07
MN1026 mux_967 inv_1017 mux_1025 0 NMOS l=6.000000000000001e-08 w=2.0000000000000002e-07
MP1027 mux_967 xor_686 mux_1025 VDD PMOS l=6.000000000000001e-08 w=4.0000000000000003e-07
MN1028 0 xor_686 mux_1025 0 NMOS l=6.000000000000001e-08 w=2.0000000000000002e-07
MP1029 0 inv_1017 mux_1025 VDD PMOS l=6.000000000000001e-08 w=4.0000000000000003e-07
MN1031 mux_972 inv_1017 mux_1030 0 NMOS l=6.000000000000001e-08 w=2.0000000000000002e-07
MP1032 mux_972 xor_686 mux_1030 VDD PMOS l=6.000000000000001e-08 w=4.0000000000000003e-07
MN1033 0 xor_686 mux_1030 0 NMOS l=6.000000000000001e-08 w=2.0000000000000002e-07
MP1034 0 inv_1017 mux_1030 VDD PMOS l=6.000000000000001e-08 w=4.0000000000000003e-07
MN1036 mux_977 inv_1017 mux_1035 0 NMOS l=6.000000000000001e-08 w=2.0000000000000002e-07
MP1037 mux_977 xor_686 mux_1035 VDD PMOS l=6.000000000000001e-08 w=4.0000000000000003e-07
MN1038 0 xor_686 mux_1035 0 NMOS l=6.000000000000001e-08 w=2.0000000000000002e-07
MP1039 0 inv_1017 mux_1035 VDD PMOS l=6.000000000000001e-08 w=4.0000000000000003e-07
MN1041 mux_982 inv_1017 mux_1040 0 NMOS l=6.000000000000001e-08 w=2.0000000000000002e-07
MP1042 mux_982 xor_686 mux_1040 VDD PMOS l=6.000000000000001e-08 w=4.0000000000000003e-07
MN1043 mux_962 xor_686 mux_1040 0 NMOS l=6.000000000000001e-08 w=2.0000000000000002e-07
MP1044 mux_962 inv_1017 mux_1040 VDD PMOS l=6.000000000000001e-08 w=4.0000000000000003e-07
MN1046 mux_987 inv_1017 mux_1045 0 NMOS l=6.000000000000001e-08 w=2.0000000000000002e-07
MP1047 mux_987 xor_686 mux_1045 VDD PMOS l=6.000000000000001e-08 w=4.0000000000000003e-07
MN1048 mux_967 xor_686 mux_1045 0 NMOS l=6.000000000000001e-08 w=2.0000000000000002e-07
MP1049 mux_967 inv_1017 mux_1045 VDD PMOS l=6.000000000000001e-08 w=4.0000000000000003e-07
MN1051 mux_992 inv_1017 mux_1050 0 NMOS l=6.000000000000001e-08 w=2.0000000000000002e-07
MP1052 mux_992 xor_686 mux_1050 VDD PMOS l=6.000000000000001e-08 w=4.0000000000000003e-07
MN1053 mux_972 xor_686 mux_1050 0 NMOS l=6.000000000000001e-08 w=2.0000000000000002e-07
MP1054 mux_972 inv_1017 mux_1050 VDD PMOS l=6.000000000000001e-08 w=4.0000000000000003e-07
MN1056 mux_997 inv_1017 mux_1055 0 NMOS l=6.000000000000001e-08 w=2.0000000000000002e-07
MP1057 mux_997 xor_686 mux_1055 VDD PMOS l=6.000000000000001e-08 w=4.0000000000000003e-07
MN1058 mux_977 xor_686 mux_1055 0 NMOS l=6.000000000000001e-08 w=2.0000000000000002e-07
MP1059 mux_977 inv_1017 mux_1055 VDD PMOS l=6.000000000000001e-08 w=4.0000000000000003e-07
MN1061 mux_1002 inv_1017 mux_1060 0 NMOS l=6.000000000000001e-08 w=2.0000000000000002e-07
MP1062 mux_1002 xor_686 mux_1060 VDD PMOS l=6.000000000000001e-08 w=4.0000000000000003e-07
MN1063 mux_982 xor_686 mux_1060 0 NMOS l=6.000000000000001e-08 w=2.0000000000000002e-07
MP1064 mux_982 inv_1017 mux_1060 VDD PMOS l=6.000000000000001e-08 w=4.0000000000000003e-07
MN1066 mux_1007 inv_1017 mux_1065 0 NMOS l=6.000000000000001e-08 w=2.0000000000000002e-07
MP1067 mux_1007 xor_686 mux_1065 VDD PMOS l=6.000000000000001e-08 w=4.0000000000000003e-07
MN1068 mux_987 xor_686 mux_1065 0 NMOS l=6.000000000000001e-08 w=2.0000000000000002e-07
MP1069 mux_987 inv_1017 mux_1065 VDD PMOS l=6.000000000000001e-08 w=4.0000000000000003e-07
MN1071 mux_1012 inv_1017 mux_1070 0 NMOS l=6.000000000000001e-08 w=2.0000000000000002e-07
MP1072 mux_1012 xor_686 mux_1070 VDD PMOS l=6.000000000000001e-08 w=4.0000000000000003e-07
MN1073 mux_992 xor_686 mux_1070 0 NMOS l=6.000000000000001e-08 w=2.0000000000000002e-07
MP1074 mux_992 inv_1017 mux_1070 VDD PMOS l=6.000000000000001e-08 w=4.0000000000000003e-07
MN1076 0 inv_1017 mux_1075 0 NMOS l=6.000000000000001e-08 w=2.0000000000000002e-07
MP1077 0 xor_686 mux_1075 VDD PMOS l=6.000000000000001e-08 w=4.0000000000000003e-07
MN1078 mux_997 xor_686 mux_1075 0 NMOS l=6.000000000000001e-08 w=2.0000000000000002e-07
MP1079 mux_997 inv_1017 mux_1075 VDD PMOS l=6.000000000000001e-08 w=4.0000000000000003e-07
MN1081 0 inv_1017 mux_1080 0 NMOS l=6.000000000000001e-08 w=2.0000000000000002e-07
MP1082 0 xor_686 mux_1080 VDD PMOS l=6.000000000000001e-08 w=4.0000000000000003e-07
MN1083 mux_1002 xor_686 mux_1080 0 NMOS l=6.000000000000001e-08 w=2.0000000000000002e-07
MP1084 mux_1002 inv_1017 mux_1080 VDD PMOS l=6.000000000000001e-08 w=4.0000000000000003e-07
MN1086 0 inv_1017 mux_1085 0 NMOS l=6.000000000000001e-08 w=2.0000000000000002e-07
MP1087 0 xor_686 mux_1085 VDD PMOS l=6.000000000000001e-08 w=4.0000000000000003e-07
MN1088 mux_1007 xor_686 mux_1085 0 NMOS l=6.000000000000001e-08 w=2.0000000000000002e-07
MP1089 mux_1007 inv_1017 mux_1085 VDD PMOS l=6.000000000000001e-08 w=4.0000000000000003e-07
MN1091 0 inv_1017 mux_1090 0 NMOS l=6.000000000000001e-08 w=2.0000000000000002e-07
MP1092 0 xor_686 mux_1090 VDD PMOS l=6.000000000000001e-08 w=4.0000000000000003e-07
MN1093 mux_1012 xor_686 mux_1090 0 NMOS l=6.000000000000001e-08 w=2.0000000000000002e-07
MP1094 mux_1012 inv_1017 mux_1090 VDD PMOS l=6.000000000000001e-08 w=4.0000000000000003e-07
MP1096 inv_1095 inv_723 VDD VDD PMOS l=6.000000000000001e-08 w=4.0000000000000003e-07
MN1097 inv_1095 inv_723 0 0 NMOS l=6.000000000000001e-08 w=2.0000000000000002e-07
MN1099 mux_1050 inv_1095 mux_1098 0 NMOS l=6.000000000000001e-08 w=2.0000000000000002e-07
MP1100 mux_1050 inv_723 mux_1098 VDD PMOS l=6.000000000000001e-08 w=4.0000000000000003e-07
MN1101 0 inv_723 mux_1098 0 NMOS l=6.000000000000001e-08 w=2.0000000000000002e-07
MP1102 0 inv_1095 mux_1098 VDD PMOS l=6.000000000000001e-08 w=4.0000000000000003e-07
MN1104 mux_1055 inv_1095 mux_1103 0 NMOS l=6.000000000000001e-08 w=2.0000000000000002e-07
MP1105 mux_1055 inv_723 mux_1103 VDD PMOS l=6.000000000000001e-08 w=4.0000000000000003e-07
MN1106 0 inv_723 mux_1103 0 NMOS l=6.000000000000001e-08 w=2.0000000000000002e-07
MP1107 0 inv_1095 mux_1103 VDD PMOS l=6.000000000000001e-08 w=4.0000000000000003e-07
MN1109 mux_1060 inv_1095 mux_1108 0 NMOS l=6.000000000000001e-08 w=2.0000000000000002e-07
MP1110 mux_1060 inv_723 mux_1108 VDD PMOS l=6.000000000000001e-08 w=4.0000000000000003e-07
MN1111 mux_1020 inv_723 mux_1108 0 NMOS l=6.000000000000001e-08 w=2.0000000000000002e-07
MP1112 mux_1020 inv_1095 mux_1108 VDD PMOS l=6.000000000000001e-08 w=4.0000000000000003e-07
MN1114 mux_1065 inv_1095 mux_1113 0 NMOS l=6.000000000000001e-08 w=2.0000000000000002e-07
MP1115 mux_1065 inv_723 mux_1113 VDD PMOS l=6.000000000000001e-08 w=4.0000000000000003e-07
MN1116 mux_1025 inv_723 mux_1113 0 NMOS l=6.000000000000001e-08 w=2.0000000000000002e-07
MP1117 mux_1025 inv_1095 mux_1113 VDD PMOS l=6.000000000000001e-08 w=4.0000000000000003e-07
MN1119 mux_1070 inv_1095 mux_1118 0 NMOS l=6.000000000000001e-08 w=2.0000000000000002e-07
MP1120 mux_1070 inv_723 mux_1118 VDD PMOS l=6.000000000000001e-08 w=4.0000000000000003e-07
MN1121 mux_1030 inv_723 mux_1118 0 NMOS l=6.000000000000001e-08 w=2.0000000000000002e-07
MP1122 mux_1030 inv_1095 mux_1118 VDD PMOS l=6.000000000000001e-08 w=4.0000000000000003e-07
MN1124 mux_1075 inv_1095 mux_1123 0 NMOS l=6.000000000000001e-08 w=2.0000000000000002e-07
MP1125 mux_1075 inv_723 mux_1123 VDD PMOS l=6.000000000000001e-08 w=4.0000000000000003e-07
MN1126 mux_1035 inv_723 mux_1123 0 NMOS l=6.000000000000001e-08 w=2.0000000000000002e-07
MP1127 mux_1035 inv_1095 mux_1123 VDD PMOS l=6.000000000000001e-08 w=4.0000000000000003e-07
MN1129 mux_1080 inv_1095 mux_1128 0 NMOS l=6.000000000000001e-08 w=2.0000000000000002e-07
MP1130 mux_1080 inv_723 mux_1128 VDD PMOS l=6.000000000000001e-08 w=4.0000000000000003e-07
MN1131 mux_1040 inv_723 mux_1128 0 NMOS l=6.000000000000001e-08 w=2.0000000000000002e-07
MP1132 mux_1040 inv_1095 mux_1128 VDD PMOS l=6.000000000000001e-08 w=4.0000000000000003e-07
MN1134 mux_1085 inv_1095 mux_1133 0 NMOS l=6.000000000000001e-08 w=2.0000000000000002e-07
MP1135 mux_1085 inv_723 mux_1133 VDD PMOS l=6.000000000000001e-08 w=4.0000000000000003e-07
MN1136 mux_1045 inv_723 mux_1133 0 NMOS l=6.000000000000001e-08 w=2.0000000000000002e-07
MP1137 mux_1045 inv_1095 mux_1133 VDD PMOS l=6.000000000000001e-08 w=4.0000000000000003e-07
MN1139 mux_1090 inv_1095 mux_1138 0 NMOS l=6.000000000000001e-08 w=2.0000000000000002e-07
MP1140 mux_1090 inv_723 mux_1138 VDD PMOS l=6.000000000000001e-08 w=4.0000000000000003e-07
MN1141 mux_1050 inv_723 mux_1138 0 NMOS l=6.000000000000001e-08 w=2.0000000000000002e-07
MP1142 mux_1050 inv_1095 mux_1138 VDD PMOS l=6.000000000000001e-08 w=4.0000000000000003e-07
MN1144 0 inv_1095 mux_1143 0 NMOS l=6.000000000000001e-08 w=2.0000000000000002e-07
MP1145 0 inv_723 mux_1143 VDD PMOS l=6.000000000000001e-08 w=4.0000000000000003e-07
MN1146 mux_1055 inv_723 mux_1143 0 NMOS l=6.000000000000001e-08 w=2.0000000000000002e-07
MP1147 mux_1055 inv_1095 mux_1143 VDD PMOS l=6.000000000000001e-08 w=4.0000000000000003e-07
MN1149 0 inv_1095 mux_1148 0 NMOS l=6.000000000000001e-08 w=2.0000000000000002e-07
MP1150 0 inv_723 mux_1148 VDD PMOS l=6.000000000000001e-08 w=4.0000000000000003e-07
MN1151 mux_1060 inv_723 mux_1148 0 NMOS l=6.000000000000001e-08 w=2.0000000000000002e-07
MP1152 mux_1060 inv_1095 mux_1148 VDD PMOS l=6.000000000000001e-08 w=4.0000000000000003e-07
MN1154 0 inv_1095 mux_1153 0 NMOS l=6.000000000000001e-08 w=2.0000000000000002e-07
MP1155 0 inv_723 mux_1153 VDD PMOS l=6.000000000000001e-08 w=4.0000000000000003e-07
MN1156 mux_1065 inv_723 mux_1153 0 NMOS l=6.000000000000001e-08 w=2.0000000000000002e-07
MP1157 mux_1065 inv_1095 mux_1153 VDD PMOS l=6.000000000000001e-08 w=4.0000000000000003e-07
MN1159 0 inv_1095 mux_1158 0 NMOS l=6.000000000000001e-08 w=2.0000000000000002e-07
MP1160 0 inv_723 mux_1158 VDD PMOS l=6.000000000000001e-08 w=4.0000000000000003e-07
MN1161 mux_1070 inv_723 mux_1158 0 NMOS l=6.000000000000001e-08 w=2.0000000000000002e-07
MP1162 mux_1070 inv_1095 mux_1158 VDD PMOS l=6.000000000000001e-08 w=4.0000000000000003e-07
MN1164 0 inv_1095 mux_1163 0 NMOS l=6.000000000000001e-08 w=2.0000000000000002e-07
MP1165 0 inv_723 mux_1163 VDD PMOS l=6.000000000000001e-08 w=4.0000000000000003e-07
MN1166 mux_1075 inv_723 mux_1163 0 NMOS l=6.000000000000001e-08 w=2.0000000000000002e-07
MP1167 mux_1075 inv_1095 mux_1163 VDD PMOS l=6.000000000000001e-08 w=4.0000000000000003e-07
MN1169 0 inv_1095 mux_1168 0 NMOS l=6.000000000000001e-08 w=2.0000000000000002e-07
MP1170 0 inv_723 mux_1168 VDD PMOS l=6.000000000000001e-08 w=4.0000000000000003e-07
MN1171 mux_1080 inv_723 mux_1168 0 NMOS l=6.000000000000001e-08 w=2.0000000000000002e-07
MP1172 mux_1080 inv_1095 mux_1168 VDD PMOS l=6.000000000000001e-08 w=4.0000000000000003e-07
MP1175 nor_1173 mux_1098 nu_1174 VDD PMOS l=6.000000000000001e-08 w=4.0000000000000003e-07
MP1176 nu_1174 inv_836 VDD VDD PMOS l=6.000000000000001e-08 w=4.0000000000000003e-07
MN1177 nor_1173 mux_1098 0 0 NMOS l=6.000000000000001e-08 w=2.0000000000000002e-07
MN1178 nor_1173 inv_836 0 0 NMOS l=6.000000000000001e-08 w=2.0000000000000002e-07
MP1180 inv_1179 nor_1173 VDD VDD PMOS l=6.000000000000001e-08 w=4.0000000000000003e-07
MN1181 inv_1179 nor_1173 0 0 NMOS l=6.000000000000001e-08 w=2.0000000000000002e-07
MP1184 nor_1182 mux_1103 nu_1183 VDD PMOS l=6.000000000000001e-08 w=4.0000000000000003e-07
MP1185 nu_1183 inv_836 VDD VDD PMOS l=6.000000000000001e-08 w=4.0000000000000003e-07
MN1186 nor_1182 mux_1103 0 0 NMOS l=6.000000000000001e-08 w=2.0000000000000002e-07
MN1187 nor_1182 inv_836 0 0 NMOS l=6.000000000000001e-08 w=2.0000000000000002e-07
MP1189 inv_1188 nor_1182 VDD VDD PMOS l=6.000000000000001e-08 w=4.0000000000000003e-07
MN1190 inv_1188 nor_1182 0 0 NMOS l=6.000000000000001e-08 w=2.0000000000000002e-07
MP1193 nor_1191 mux_1108 nu_1192 VDD PMOS l=6.000000000000001e-08 w=4.0000000000000003e-07
MP1194 nu_1192 inv_836 VDD VDD PMOS l=6.000000000000001e-08 w=4.0000000000000003e-07
MN1195 nor_1191 mux_1108 0 0 NMOS l=6.000000000000001e-08 w=2.0000000000000002e-07
MN1196 nor_1191 inv_836 0 0 NMOS l=6.000000000000001e-08 w=2.0000000000000002e-07
MP1198 inv_1197 nor_1191 VDD VDD PMOS l=6.000000000000001e-08 w=4.0000000000000003e-07
MN1199 inv_1197 nor_1191 0 0 NMOS l=6.000000000000001e-08 w=2.0000000000000002e-07
MP1202 nor_1200 mux_1113 nu_1201 VDD PMOS l=6.000000000000001e-08 w=4.0000000000000003e-07
MP1203 nu_1201 inv_836 VDD VDD PMOS l=6.000000000000001e-08 w=4.0000000000000003e-07
MN1204 nor_1200 mux_1113 0 0 NMOS l=6.000000000000001e-08 w=2.0000000000000002e-07
MN1205 nor_1200 inv_836 0 0 NMOS l=6.000000000000001e-08 w=2.0000000000000002e-07
MP1207 inv_1206 nor_1200 VDD VDD PMOS l=6.000000000000001e-08 w=4.0000000000000003e-07
MN1208 inv_1206 nor_1200 0 0 NMOS l=6.000000000000001e-08 w=2.0000000000000002e-07
MP1211 nor_1209 mux_1118 nu_1210 VDD PMOS l=6.000000000000001e-08 w=4.0000000000000003e-07
MP1212 nu_1210 inv_836 VDD VDD PMOS l=6.000000000000001e-08 w=4.0000000000000003e-07
MN1213 nor_1209 mux_1118 0 0 NMOS l=6.000000000000001e-08 w=2.0000000000000002e-07
MN1214 nor_1209 inv_836 0 0 NMOS l=6.000000000000001e-08 w=2.0000000000000002e-07
MP1216 inv_1215 nor_1209 VDD VDD PMOS l=6.000000000000001e-08 w=4.0000000000000003e-07
MN1217 inv_1215 nor_1209 0 0 NMOS l=6.000000000000001e-08 w=2.0000000000000002e-07
MP1220 nor_1218 mux_1123 nu_1219 VDD PMOS l=6.000000000000001e-08 w=4.0000000000000003e-07
MP1221 nu_1219 inv_836 VDD VDD PMOS l=6.000000000000001e-08 w=4.0000000000000003e-07
MN1222 nor_1218 mux_1123 0 0 NMOS l=6.000000000000001e-08 w=2.0000000000000002e-07
MN1223 nor_1218 inv_836 0 0 NMOS l=6.000000000000001e-08 w=2.0000000000000002e-07
MP1225 inv_1224 nor_1218 VDD VDD PMOS l=6.000000000000001e-08 w=4.0000000000000003e-07
MN1226 inv_1224 nor_1218 0 0 NMOS l=6.000000000000001e-08 w=2.0000000000000002e-07
MP1229 nor_1227 mux_1128 nu_1228 VDD PMOS l=6.000000000000001e-08 w=4.0000000000000003e-07
MP1230 nu_1228 inv_836 VDD VDD PMOS l=6.000000000000001e-08 w=4.0000000000000003e-07
MN1231 nor_1227 mux_1128 0 0 NMOS l=6.000000000000001e-08 w=2.0000000000000002e-07
MN1232 nor_1227 inv_836 0 0 NMOS l=6.000000000000001e-08 w=2.0000000000000002e-07
MP1234 inv_1233 nor_1227 VDD VDD PMOS l=6.000000000000001e-08 w=4.0000000000000003e-07
MN1235 inv_1233 nor_1227 0 0 NMOS l=6.000000000000001e-08 w=2.0000000000000002e-07
MP1238 nor_1236 mux_1133 nu_1237 VDD PMOS l=6.000000000000001e-08 w=4.0000000000000003e-07
MP1239 nu_1237 inv_836 VDD VDD PMOS l=6.000000000000001e-08 w=4.0000000000000003e-07
MN1240 nor_1236 mux_1133 0 0 NMOS l=6.000000000000001e-08 w=2.0000000000000002e-07
MN1241 nor_1236 inv_836 0 0 NMOS l=6.000000000000001e-08 w=2.0000000000000002e-07
MP1243 inv_1242 nor_1236 VDD VDD PMOS l=6.000000000000001e-08 w=4.0000000000000003e-07
MN1244 inv_1242 nor_1236 0 0 NMOS l=6.000000000000001e-08 w=2.0000000000000002e-07
MP1247 nor_1245 mux_1138 nu_1246 VDD PMOS l=6.000000000000001e-08 w=4.0000000000000003e-07
MP1248 nu_1246 inv_836 VDD VDD PMOS l=6.000000000000001e-08 w=4.0000000000000003e-07
MN1249 nor_1245 mux_1138 0 0 NMOS l=6.000000000000001e-08 w=2.0000000000000002e-07
MN1250 nor_1245 inv_836 0 0 NMOS l=6.000000000000001e-08 w=2.0000000000000002e-07
MP1252 inv_1251 nor_1245 VDD VDD PMOS l=6.000000000000001e-08 w=4.0000000000000003e-07
MN1253 inv_1251 nor_1245 0 0 NMOS l=6.000000000000001e-08 w=2.0000000000000002e-07
MP1256 nor_1254 mux_1143 nu_1255 VDD PMOS l=6.000000000000001e-08 w=4.0000000000000003e-07
MP1257 nu_1255 inv_836 VDD VDD PMOS l=6.000000000000001e-08 w=4.0000000000000003e-07
MN1258 nor_1254 mux_1143 0 0 NMOS l=6.000000000000001e-08 w=2.0000000000000002e-07
MN1259 nor_1254 inv_836 0 0 NMOS l=6.000000000000001e-08 w=2.0000000000000002e-07
MP1261 inv_1260 nor_1254 VDD VDD PMOS l=6.000000000000001e-08 w=4.0000000000000003e-07
MN1262 inv_1260 nor_1254 0 0 NMOS l=6.000000000000001e-08 w=2.0000000000000002e-07
MP1265 nor_1263 mux_1148 nu_1264 VDD PMOS l=6.000000000000001e-08 w=4.0000000000000003e-07
MP1266 nu_1264 inv_836 VDD VDD PMOS l=6.000000000000001e-08 w=4.0000000000000003e-07
MN1267 nor_1263 mux_1148 0 0 NMOS l=6.000000000000001e-08 w=2.0000000000000002e-07
MN1268 nor_1263 inv_836 0 0 NMOS l=6.000000000000001e-08 w=2.0000000000000002e-07
MP1270 inv_1269 nor_1263 VDD VDD PMOS l=6.000000000000001e-08 w=4.0000000000000003e-07
MN1271 inv_1269 nor_1263 0 0 NMOS l=6.000000000000001e-08 w=2.0000000000000002e-07
MP1274 nor_1272 mux_1153 nu_1273 VDD PMOS l=6.000000000000001e-08 w=4.0000000000000003e-07
MP1275 nu_1273 inv_836 VDD VDD PMOS l=6.000000000000001e-08 w=4.0000000000000003e-07
MN1276 nor_1272 mux_1153 0 0 NMOS l=6.000000000000001e-08 w=2.0000000000000002e-07
MN1277 nor_1272 inv_836 0 0 NMOS l=6.000000000000001e-08 w=2.0000000000000002e-07
MP1279 inv_1278 nor_1272 VDD VDD PMOS l=6.000000000000001e-08 w=4.0000000000000003e-07
MN1280 inv_1278 nor_1272 0 0 NMOS l=6.000000000000001e-08 w=2.0000000000000002e-07
MP1283 nor_1281 mux_1158 nu_1282 VDD PMOS l=6.000000000000001e-08 w=4.0000000000000003e-07
MP1284 nu_1282 inv_836 VDD VDD PMOS l=6.000000000000001e-08 w=4.0000000000000003e-07
MN1285 nor_1281 mux_1158 0 0 NMOS l=6.000000000000001e-08 w=2.0000000000000002e-07
MN1286 nor_1281 inv_836 0 0 NMOS l=6.000000000000001e-08 w=2.0000000000000002e-07
MP1288 inv_1287 nor_1281 VDD VDD PMOS l=6.000000000000001e-08 w=4.0000000000000003e-07
MN1289 inv_1287 nor_1281 0 0 NMOS l=6.000000000000001e-08 w=2.0000000000000002e-07
MP1292 nor_1290 mux_1163 nu_1291 VDD PMOS l=6.000000000000001e-08 w=4.0000000000000003e-07
MP1293 nu_1291 inv_836 VDD VDD PMOS l=6.000000000000001e-08 w=4.0000000000000003e-07
MN1294 nor_1290 mux_1163 0 0 NMOS l=6.000000000000001e-08 w=2.0000000000000002e-07
MN1295 nor_1290 inv_836 0 0 NMOS l=6.000000000000001e-08 w=2.0000000000000002e-07
MP1297 inv_1296 nor_1290 VDD VDD PMOS l=6.000000000000001e-08 w=4.0000000000000003e-07
MN1298 inv_1296 nor_1290 0 0 NMOS l=6.000000000000001e-08 w=2.0000000000000002e-07
MP1301 nor_1299 mux_1168 nu_1300 VDD PMOS l=6.000000000000001e-08 w=4.0000000000000003e-07
MP1302 nu_1300 inv_836 VDD VDD PMOS l=6.000000000000001e-08 w=4.0000000000000003e-07
MN1303 nor_1299 mux_1168 0 0 NMOS l=6.000000000000001e-08 w=2.0000000000000002e-07
MN1304 nor_1299 inv_836 0 0 NMOS l=6.000000000000001e-08 w=2.0000000000000002e-07
MP1306 inv_1305 nor_1299 VDD VDD PMOS l=6.000000000000001e-08 w=4.0000000000000003e-07
MN1307 inv_1305 nor_1299 0 0 NMOS l=6.000000000000001e-08 w=2.0000000000000002e-07
MP1310 inv_1309 inv_1179 VDD VDD PMOS l=6.000000000000001e-08 w=4.0000000000000003e-07
MN1311 inv_1309 inv_1179 0 0 NMOS l=6.000000000000001e-08 w=2.0000000000000002e-07
MP1313 inv_1312 xor_192 VDD VDD PMOS l=6.000000000000001e-08 w=4.0000000000000003e-07
MN1314 inv_1312 xor_192 0 0 NMOS l=6.000000000000001e-08 w=2.0000000000000002e-07
MN1315 inv_1179 inv_1312 xor_1308 0 NMOS l=6.000000000000001e-08 w=2.0000000000000002e-07
MP1316 inv_1179 xor_192 xor_1308 VDD PMOS l=6.000000000000001e-08 w=4.0000000000000003e-07
MN1317 inv_1309 xor_192 xor_1308 0 NMOS l=6.000000000000001e-08 w=2.0000000000000002e-07
MP1318 inv_1309 inv_1312 xor_1308 VDD PMOS l=6.000000000000001e-08 w=4.0000000000000003e-07
MP1321 inv_1320 inv_1188 VDD VDD PMOS l=6.000000000000001e-08 w=4.0000000000000003e-07
MN1322 inv_1320 inv_1188 0 0 NMOS l=6.000000000000001e-08 w=2.0000000000000002e-07
MP1324 inv_1323 xor_192 VDD VDD PMOS l=6.000000000000001e-08 w=4.0000000000000003e-07
MN1325 inv_1323 xor_192 0 0 NMOS l=6.000000000000001e-08 w=2.0000000000000002e-07
MN1326 inv_1188 inv_1323 xor_1319 0 NMOS l=6.000000000000001e-08 w=2.0000000000000002e-07
MP1327 inv_1188 xor_192 xor_1319 VDD PMOS l=6.000000000000001e-08 w=4.0000000000000003e-07
MN1328 inv_1320 xor_192 xor_1319 0 NMOS l=6.000000000000001e-08 w=2.0000000000000002e-07
MP1329 inv_1320 inv_1323 xor_1319 VDD PMOS l=6.000000000000001e-08 w=4.0000000000000003e-07
MP1332 inv_1331 inv_1197 VDD VDD PMOS l=6.000000000000001e-08 w=4.0000000000000003e-07
MN1333 inv_1331 inv_1197 0 0 NMOS l=6.000000000000001e-08 w=2.0000000000000002e-07
MP1335 inv_1334 xor_192 VDD VDD PMOS l=6.000000000000001e-08 w=4.0000000000000003e-07
MN1336 inv_1334 xor_192 0 0 NMOS l=6.000000000000001e-08 w=2.0000000000000002e-07
MN1337 inv_1197 inv_1334 xor_1330 0 NMOS l=6.000000000000001e-08 w=2.0000000000000002e-07
MP1338 inv_1197 xor_192 xor_1330 VDD PMOS l=6.000000000000001e-08 w=4.0000000000000003e-07
MN1339 inv_1331 xor_192 xor_1330 0 NMOS l=6.000000000000001e-08 w=2.0000000000000002e-07
MP1340 inv_1331 inv_1334 xor_1330 VDD PMOS l=6.000000000000001e-08 w=4.0000000000000003e-07
MP1343 inv_1342 inv_1206 VDD VDD PMOS l=6.000000000000001e-08 w=4.0000000000000003e-07
MN1344 inv_1342 inv_1206 0 0 NMOS l=6.000000000000001e-08 w=2.0000000000000002e-07
MP1346 inv_1345 xor_192 VDD VDD PMOS l=6.000000000000001e-08 w=4.0000000000000003e-07
MN1347 inv_1345 xor_192 0 0 NMOS l=6.000000000000001e-08 w=2.0000000000000002e-07
MN1348 inv_1206 inv_1345 xor_1341 0 NMOS l=6.000000000000001e-08 w=2.0000000000000002e-07
MP1349 inv_1206 xor_192 xor_1341 VDD PMOS l=6.000000000000001e-08 w=4.0000000000000003e-07
MN1350 inv_1342 xor_192 xor_1341 0 NMOS l=6.000000000000001e-08 w=2.0000000000000002e-07
MP1351 inv_1342 inv_1345 xor_1341 VDD PMOS l=6.000000000000001e-08 w=4.0000000000000003e-07
MP1354 inv_1353 inv_1215 VDD VDD PMOS l=6.000000000000001e-08 w=4.0000000000000003e-07
MN1355 inv_1353 inv_1215 0 0 NMOS l=6.000000000000001e-08 w=2.0000000000000002e-07
MP1357 inv_1356 xor_192 VDD VDD PMOS l=6.000000000000001e-08 w=4.0000000000000003e-07
MN1358 inv_1356 xor_192 0 0 NMOS l=6.000000000000001e-08 w=2.0000000000000002e-07
MN1359 inv_1215 inv_1356 xor_1352 0 NMOS l=6.000000000000001e-08 w=2.0000000000000002e-07
MP1360 inv_1215 xor_192 xor_1352 VDD PMOS l=6.000000000000001e-08 w=4.0000000000000003e-07
MN1361 inv_1353 xor_192 xor_1352 0 NMOS l=6.000000000000001e-08 w=2.0000000000000002e-07
MP1362 inv_1353 inv_1356 xor_1352 VDD PMOS l=6.000000000000001e-08 w=4.0000000000000003e-07
MP1365 inv_1364 inv_1224 VDD VDD PMOS l=6.000000000000001e-08 w=4.0000000000000003e-07
MN1366 inv_1364 inv_1224 0 0 NMOS l=6.000000000000001e-08 w=2.0000000000000002e-07
MP1368 inv_1367 xor_192 VDD VDD PMOS l=6.000000000000001e-08 w=4.0000000000000003e-07
MN1369 inv_1367 xor_192 0 0 NMOS l=6.000000000000001e-08 w=2.0000000000000002e-07
MN1370 inv_1224 inv_1367 xor_1363 0 NMOS l=6.000000000000001e-08 w=2.0000000000000002e-07
MP1371 inv_1224 xor_192 xor_1363 VDD PMOS l=6.000000000000001e-08 w=4.0000000000000003e-07
MN1372 inv_1364 xor_192 xor_1363 0 NMOS l=6.000000000000001e-08 w=2.0000000000000002e-07
MP1373 inv_1364 inv_1367 xor_1363 VDD PMOS l=6.000000000000001e-08 w=4.0000000000000003e-07
MP1376 inv_1375 inv_1233 VDD VDD PMOS l=6.000000000000001e-08 w=4.0000000000000003e-07
MN1377 inv_1375 inv_1233 0 0 NMOS l=6.000000000000001e-08 w=2.0000000000000002e-07
MP1379 inv_1378 xor_192 VDD VDD PMOS l=6.000000000000001e-08 w=4.0000000000000003e-07
MN1380 inv_1378 xor_192 0 0 NMOS l=6.000000000000001e-08 w=2.0000000000000002e-07
MN1381 inv_1233 inv_1378 xor_1374 0 NMOS l=6.000000000000001e-08 w=2.0000000000000002e-07
MP1382 inv_1233 xor_192 xor_1374 VDD PMOS l=6.000000000000001e-08 w=4.0000000000000003e-07
MN1383 inv_1375 xor_192 xor_1374 0 NMOS l=6.000000000000001e-08 w=2.0000000000000002e-07
MP1384 inv_1375 inv_1378 xor_1374 VDD PMOS l=6.000000000000001e-08 w=4.0000000000000003e-07
MP1387 inv_1386 inv_1242 VDD VDD PMOS l=6.000000000000001e-08 w=4.0000000000000003e-07
MN1388 inv_1386 inv_1242 0 0 NMOS l=6.000000000000001e-08 w=2.0000000000000002e-07
MP1390 inv_1389 xor_192 VDD VDD PMOS l=6.000000000000001e-08 w=4.0000000000000003e-07
MN1391 inv_1389 xor_192 0 0 NMOS l=6.000000000000001e-08 w=2.0000000000000002e-07
MN1392 inv_1242 inv_1389 xor_1385 0 NMOS l=6.000000000000001e-08 w=2.0000000000000002e-07
MP1393 inv_1242 xor_192 xor_1385 VDD PMOS l=6.000000000000001e-08 w=4.0000000000000003e-07
MN1394 inv_1386 xor_192 xor_1385 0 NMOS l=6.000000000000001e-08 w=2.0000000000000002e-07
MP1395 inv_1386 inv_1389 xor_1385 VDD PMOS l=6.000000000000001e-08 w=4.0000000000000003e-07
MP1398 inv_1397 inv_1251 VDD VDD PMOS l=6.000000000000001e-08 w=4.0000000000000003e-07
MN1399 inv_1397 inv_1251 0 0 NMOS l=6.000000000000001e-08 w=2.0000000000000002e-07
MP1401 inv_1400 xor_192 VDD VDD PMOS l=6.000000000000001e-08 w=4.0000000000000003e-07
MN1402 inv_1400 xor_192 0 0 NMOS l=6.000000000000001e-08 w=2.0000000000000002e-07
MN1403 inv_1251 inv_1400 xor_1396 0 NMOS l=6.000000000000001e-08 w=2.0000000000000002e-07
MP1404 inv_1251 xor_192 xor_1396 VDD PMOS l=6.000000000000001e-08 w=4.0000000000000003e-07
MN1405 inv_1397 xor_192 xor_1396 0 NMOS l=6.000000000000001e-08 w=2.0000000000000002e-07
MP1406 inv_1397 inv_1400 xor_1396 VDD PMOS l=6.000000000000001e-08 w=4.0000000000000003e-07
MP1409 inv_1408 inv_1260 VDD VDD PMOS l=6.000000000000001e-08 w=4.0000000000000003e-07
MN1410 inv_1408 inv_1260 0 0 NMOS l=6.000000000000001e-08 w=2.0000000000000002e-07
MP1412 inv_1411 xor_192 VDD VDD PMOS l=6.000000000000001e-08 w=4.0000000000000003e-07
MN1413 inv_1411 xor_192 0 0 NMOS l=6.000000000000001e-08 w=2.0000000000000002e-07
MN1414 inv_1260 inv_1411 xor_1407 0 NMOS l=6.000000000000001e-08 w=2.0000000000000002e-07
MP1415 inv_1260 xor_192 xor_1407 VDD PMOS l=6.000000000000001e-08 w=4.0000000000000003e-07
MN1416 inv_1408 xor_192 xor_1407 0 NMOS l=6.000000000000001e-08 w=2.0000000000000002e-07
MP1417 inv_1408 inv_1411 xor_1407 VDD PMOS l=6.000000000000001e-08 w=4.0000000000000003e-07
MP1420 inv_1419 inv_1269 VDD VDD PMOS l=6.000000000000001e-08 w=4.0000000000000003e-07
MN1421 inv_1419 inv_1269 0 0 NMOS l=6.000000000000001e-08 w=2.0000000000000002e-07
MP1423 inv_1422 xor_192 VDD VDD PMOS l=6.000000000000001e-08 w=4.0000000000000003e-07
MN1424 inv_1422 xor_192 0 0 NMOS l=6.000000000000001e-08 w=2.0000000000000002e-07
MN1425 inv_1269 inv_1422 xor_1418 0 NMOS l=6.000000000000001e-08 w=2.0000000000000002e-07
MP1426 inv_1269 xor_192 xor_1418 VDD PMOS l=6.000000000000001e-08 w=4.0000000000000003e-07
MN1427 inv_1419 xor_192 xor_1418 0 NMOS l=6.000000000000001e-08 w=2.0000000000000002e-07
MP1428 inv_1419 inv_1422 xor_1418 VDD PMOS l=6.000000000000001e-08 w=4.0000000000000003e-07
MP1431 inv_1430 inv_1278 VDD VDD PMOS l=6.000000000000001e-08 w=4.0000000000000003e-07
MN1432 inv_1430 inv_1278 0 0 NMOS l=6.000000000000001e-08 w=2.0000000000000002e-07
MP1434 inv_1433 xor_192 VDD VDD PMOS l=6.000000000000001e-08 w=4.0000000000000003e-07
MN1435 inv_1433 xor_192 0 0 NMOS l=6.000000000000001e-08 w=2.0000000000000002e-07
MN1436 inv_1278 inv_1433 xor_1429 0 NMOS l=6.000000000000001e-08 w=2.0000000000000002e-07
MP1437 inv_1278 xor_192 xor_1429 VDD PMOS l=6.000000000000001e-08 w=4.0000000000000003e-07
MN1438 inv_1430 xor_192 xor_1429 0 NMOS l=6.000000000000001e-08 w=2.0000000000000002e-07
MP1439 inv_1430 inv_1433 xor_1429 VDD PMOS l=6.000000000000001e-08 w=4.0000000000000003e-07
MP1442 inv_1441 inv_1287 VDD VDD PMOS l=6.000000000000001e-08 w=4.0000000000000003e-07
MN1443 inv_1441 inv_1287 0 0 NMOS l=6.000000000000001e-08 w=2.0000000000000002e-07
MP1445 inv_1444 xor_192 VDD VDD PMOS l=6.000000000000001e-08 w=4.0000000000000003e-07
MN1446 inv_1444 xor_192 0 0 NMOS l=6.000000000000001e-08 w=2.0000000000000002e-07
MN1447 inv_1287 inv_1444 xor_1440 0 NMOS l=6.000000000000001e-08 w=2.0000000000000002e-07
MP1448 inv_1287 xor_192 xor_1440 VDD PMOS l=6.000000000000001e-08 w=4.0000000000000003e-07
MN1449 inv_1441 xor_192 xor_1440 0 NMOS l=6.000000000000001e-08 w=2.0000000000000002e-07
MP1450 inv_1441 inv_1444 xor_1440 VDD PMOS l=6.000000000000001e-08 w=4.0000000000000003e-07
MP1453 inv_1452 inv_1296 VDD VDD PMOS l=6.000000000000001e-08 w=4.0000000000000003e-07
MN1454 inv_1452 inv_1296 0 0 NMOS l=6.000000000000001e-08 w=2.0000000000000002e-07
MP1456 inv_1455 xor_192 VDD VDD PMOS l=6.000000000000001e-08 w=4.0000000000000003e-07
MN1457 inv_1455 xor_192 0 0 NMOS l=6.000000000000001e-08 w=2.0000000000000002e-07
MN1458 inv_1296 inv_1455 xor_1451 0 NMOS l=6.000000000000001e-08 w=2.0000000000000002e-07
MP1459 inv_1296 xor_192 xor_1451 VDD PMOS l=6.000000000000001e-08 w=4.0000000000000003e-07
MN1460 inv_1452 xor_192 xor_1451 0 NMOS l=6.000000000000001e-08 w=2.0000000000000002e-07
MP1461 inv_1452 inv_1455 xor_1451 VDD PMOS l=6.000000000000001e-08 w=4.0000000000000003e-07
MP1464 inv_1463 inv_1305 VDD VDD PMOS l=6.000000000000001e-08 w=4.0000000000000003e-07
MN1465 inv_1463 inv_1305 0 0 NMOS l=6.000000000000001e-08 w=2.0000000000000002e-07
MP1467 inv_1466 xor_192 VDD VDD PMOS l=6.000000000000001e-08 w=4.0000000000000003e-07
MN1468 inv_1466 xor_192 0 0 NMOS l=6.000000000000001e-08 w=2.0000000000000002e-07
MN1469 inv_1305 inv_1466 xor_1462 0 NMOS l=6.000000000000001e-08 w=2.0000000000000002e-07
MP1470 inv_1305 xor_192 xor_1462 VDD PMOS l=6.000000000000001e-08 w=4.0000000000000003e-07
MN1471 inv_1463 xor_192 xor_1462 0 NMOS l=6.000000000000001e-08 w=2.0000000000000002e-07
MP1472 inv_1463 inv_1466 xor_1462 VDD PMOS l=6.000000000000001e-08 w=4.0000000000000003e-07
MP1474 inv_1473 Cin0_17 VDD VDD PMOS l=6.000000000000001e-08 w=4.0000000000000003e-07
MN1475 inv_1473 Cin0_17 0 0 NMOS l=6.000000000000001e-08 w=2.0000000000000002e-07
MP1477 inv_1476 xor_1308 VDD VDD PMOS l=6.000000000000001e-08 w=4.0000000000000003e-07
MN1478 inv_1476 xor_1308 0 0 NMOS l=6.000000000000001e-08 w=2.0000000000000002e-07
MN1480 Cin0_17 inv_1476 xor_1479 0 NMOS l=6.000000000000001e-08 w=2.0000000000000002e-07
MP1481 Cin0_17 xor_1308 xor_1479 VDD PMOS l=6.000000000000001e-08 w=4.0000000000000003e-07
MN1482 inv_1473 xor_1308 xor_1479 0 NMOS l=6.000000000000001e-08 w=2.0000000000000002e-07
MP1483 inv_1473 inv_1476 xor_1479 VDD PMOS l=6.000000000000001e-08 w=4.0000000000000003e-07
MP1485 inv_1484 xor_1479 VDD VDD PMOS l=6.000000000000001e-08 w=4.0000000000000003e-07
MN1486 inv_1484 xor_1479 0 0 NMOS l=6.000000000000001e-08 w=2.0000000000000002e-07
MP1488 inv_1487 xor_192 VDD VDD PMOS l=6.000000000000001e-08 w=4.0000000000000003e-07
MN1489 inv_1487 xor_192 0 0 NMOS l=6.000000000000001e-08 w=2.0000000000000002e-07
MN1491 xor_1479 inv_1487 xor_1490 0 NMOS l=6.000000000000001e-08 w=2.0000000000000002e-07
MP1492 xor_1479 xor_192 xor_1490 VDD PMOS l=6.000000000000001e-08 w=4.0000000000000003e-07
MN1493 inv_1484 xor_192 xor_1490 0 NMOS l=6.000000000000001e-08 w=2.0000000000000002e-07
MP1494 inv_1484 inv_1487 xor_1490 VDD PMOS l=6.000000000000001e-08 w=4.0000000000000003e-07
MN1496 xor_192 xor_1479 cout_1495 0 NMOS l=6.000000000000001e-08 w=2.0000000000000002e-07
MP1497 xor_192 inv_1484 cout_1495 VDD PMOS l=6.000000000000001e-08 w=4.0000000000000003e-07
MN1498 Cin0_17 inv_1484 cout_1495 0 NMOS l=6.000000000000001e-08 w=2.0000000000000002e-07
MP1499 Cin0_17 xor_1479 cout_1495 VDD PMOS l=6.000000000000001e-08 w=4.0000000000000003e-07
MP1501 inv_1500 Cin1_18 VDD VDD PMOS l=6.000000000000001e-08 w=4.0000000000000003e-07
MN1502 inv_1500 Cin1_18 0 0 NMOS l=6.000000000000001e-08 w=2.0000000000000002e-07
MP1504 inv_1503 xor_1319 VDD VDD PMOS l=6.000000000000001e-08 w=4.0000000000000003e-07
MN1505 inv_1503 xor_1319 0 0 NMOS l=6.000000000000001e-08 w=2.0000000000000002e-07
MN1507 Cin1_18 inv_1503 xor_1506 0 NMOS l=6.000000000000001e-08 w=2.0000000000000002e-07
MP1508 Cin1_18 xor_1319 xor_1506 VDD PMOS l=6.000000000000001e-08 w=4.0000000000000003e-07
MN1509 inv_1500 xor_1319 xor_1506 0 NMOS l=6.000000000000001e-08 w=2.0000000000000002e-07
MP1510 inv_1500 inv_1503 xor_1506 VDD PMOS l=6.000000000000001e-08 w=4.0000000000000003e-07
MP1512 inv_1511 xor_1506 VDD VDD PMOS l=6.000000000000001e-08 w=4.0000000000000003e-07
MN1513 inv_1511 xor_1506 0 0 NMOS l=6.000000000000001e-08 w=2.0000000000000002e-07
MP1515 inv_1514 cout_1495 VDD VDD PMOS l=6.000000000000001e-08 w=4.0000000000000003e-07
MN1516 inv_1514 cout_1495 0 0 NMOS l=6.000000000000001e-08 w=2.0000000000000002e-07
MN1518 xor_1506 inv_1514 xor_1517 0 NMOS l=6.000000000000001e-08 w=2.0000000000000002e-07
MP1519 xor_1506 cout_1495 xor_1517 VDD PMOS l=6.000000000000001e-08 w=4.0000000000000003e-07
MN1520 inv_1511 cout_1495 xor_1517 0 NMOS l=6.000000000000001e-08 w=2.0000000000000002e-07
MP1521 inv_1511 inv_1514 xor_1517 VDD PMOS l=6.000000000000001e-08 w=4.0000000000000003e-07
MN1523 cout_1495 xor_1506 cout_1522 0 NMOS l=6.000000000000001e-08 w=2.0000000000000002e-07
MP1524 cout_1495 inv_1511 cout_1522 VDD PMOS l=6.000000000000001e-08 w=4.0000000000000003e-07
MN1525 Cin1_18 inv_1511 cout_1522 0 NMOS l=6.000000000000001e-08 w=2.0000000000000002e-07
MP1526 Cin1_18 xor_1506 cout_1522 VDD PMOS l=6.000000000000001e-08 w=4.0000000000000003e-07
MP1528 inv_1527 Cin2_19 VDD VDD PMOS l=6.000000000000001e-08 w=4.0000000000000003e-07
MN1529 inv_1527 Cin2_19 0 0 NMOS l=6.000000000000001e-08 w=2.0000000000000002e-07
MP1531 inv_1530 xor_1330 VDD VDD PMOS l=6.000000000000001e-08 w=4.0000000000000003e-07
MN1532 inv_1530 xor_1330 0 0 NMOS l=6.000000000000001e-08 w=2.0000000000000002e-07
MN1534 Cin2_19 inv_1530 xor_1533 0 NMOS l=6.000000000000001e-08 w=2.0000000000000002e-07
MP1535 Cin2_19 xor_1330 xor_1533 VDD PMOS l=6.000000000000001e-08 w=4.0000000000000003e-07
MN1536 inv_1527 xor_1330 xor_1533 0 NMOS l=6.000000000000001e-08 w=2.0000000000000002e-07
MP1537 inv_1527 inv_1530 xor_1533 VDD PMOS l=6.000000000000001e-08 w=4.0000000000000003e-07
MP1539 inv_1538 xor_1533 VDD VDD PMOS l=6.000000000000001e-08 w=4.0000000000000003e-07
MN1540 inv_1538 xor_1533 0 0 NMOS l=6.000000000000001e-08 w=2.0000000000000002e-07
MP1542 inv_1541 cout_1522 VDD VDD PMOS l=6.000000000000001e-08 w=4.0000000000000003e-07
MN1543 inv_1541 cout_1522 0 0 NMOS l=6.000000000000001e-08 w=2.0000000000000002e-07
MN1545 xor_1533 inv_1541 xor_1544 0 NMOS l=6.000000000000001e-08 w=2.0000000000000002e-07
MP1546 xor_1533 cout_1522 xor_1544 VDD PMOS l=6.000000000000001e-08 w=4.0000000000000003e-07
MN1547 inv_1538 cout_1522 xor_1544 0 NMOS l=6.000000000000001e-08 w=2.0000000000000002e-07
MP1548 inv_1538 inv_1541 xor_1544 VDD PMOS l=6.000000000000001e-08 w=4.0000000000000003e-07
MN1550 cout_1522 xor_1533 cout_1549 0 NMOS l=6.000000000000001e-08 w=2.0000000000000002e-07
MP1551 cout_1522 inv_1538 cout_1549 VDD PMOS l=6.000000000000001e-08 w=4.0000000000000003e-07
MN1552 Cin2_19 inv_1538 cout_1549 0 NMOS l=6.000000000000001e-08 w=2.0000000000000002e-07
MP1553 Cin2_19 xor_1533 cout_1549 VDD PMOS l=6.000000000000001e-08 w=4.0000000000000003e-07
MP1555 inv_1554 Cin3_20 VDD VDD PMOS l=6.000000000000001e-08 w=4.0000000000000003e-07
MN1556 inv_1554 Cin3_20 0 0 NMOS l=6.000000000000001e-08 w=2.0000000000000002e-07
MP1558 inv_1557 xor_1341 VDD VDD PMOS l=6.000000000000001e-08 w=4.0000000000000003e-07
MN1559 inv_1557 xor_1341 0 0 NMOS l=6.000000000000001e-08 w=2.0000000000000002e-07
MN1561 Cin3_20 inv_1557 xor_1560 0 NMOS l=6.000000000000001e-08 w=2.0000000000000002e-07
MP1562 Cin3_20 xor_1341 xor_1560 VDD PMOS l=6.000000000000001e-08 w=4.0000000000000003e-07
MN1563 inv_1554 xor_1341 xor_1560 0 NMOS l=6.000000000000001e-08 w=2.0000000000000002e-07
MP1564 inv_1554 inv_1557 xor_1560 VDD PMOS l=6.000000000000001e-08 w=4.0000000000000003e-07
MP1566 inv_1565 xor_1560 VDD VDD PMOS l=6.000000000000001e-08 w=4.0000000000000003e-07
MN1567 inv_1565 xor_1560 0 0 NMOS l=6.000000000000001e-08 w=2.0000000000000002e-07
MP1569 inv_1568 cout_1549 VDD VDD PMOS l=6.000000000000001e-08 w=4.0000000000000003e-07
MN1570 inv_1568 cout_1549 0 0 NMOS l=6.000000000000001e-08 w=2.0000000000000002e-07
MN1572 xor_1560 inv_1568 xor_1571 0 NMOS l=6.000000000000001e-08 w=2.0000000000000002e-07
MP1573 xor_1560 cout_1549 xor_1571 VDD PMOS l=6.000000000000001e-08 w=4.0000000000000003e-07
MN1574 inv_1565 cout_1549 xor_1571 0 NMOS l=6.000000000000001e-08 w=2.0000000000000002e-07
MP1575 inv_1565 inv_1568 xor_1571 VDD PMOS l=6.000000000000001e-08 w=4.0000000000000003e-07
MN1577 cout_1549 xor_1560 cout_1576 0 NMOS l=6.000000000000001e-08 w=2.0000000000000002e-07
MP1578 cout_1549 inv_1565 cout_1576 VDD PMOS l=6.000000000000001e-08 w=4.0000000000000003e-07
MN1579 Cin3_20 inv_1565 cout_1576 0 NMOS l=6.000000000000001e-08 w=2.0000000000000002e-07
MP1580 Cin3_20 xor_1560 cout_1576 VDD PMOS l=6.000000000000001e-08 w=4.0000000000000003e-07
MP1582 inv_1581 Cin4_21 VDD VDD PMOS l=6.000000000000001e-08 w=4.0000000000000003e-07
MN1583 inv_1581 Cin4_21 0 0 NMOS l=6.000000000000001e-08 w=2.0000000000000002e-07
MP1585 inv_1584 xor_1352 VDD VDD PMOS l=6.000000000000001e-08 w=4.0000000000000003e-07
MN1586 inv_1584 xor_1352 0 0 NMOS l=6.000000000000001e-08 w=2.0000000000000002e-07
MN1588 Cin4_21 inv_1584 xor_1587 0 NMOS l=6.000000000000001e-08 w=2.0000000000000002e-07
MP1589 Cin4_21 xor_1352 xor_1587 VDD PMOS l=6.000000000000001e-08 w=4.0000000000000003e-07
MN1590 inv_1581 xor_1352 xor_1587 0 NMOS l=6.000000000000001e-08 w=2.0000000000000002e-07
MP1591 inv_1581 inv_1584 xor_1587 VDD PMOS l=6.000000000000001e-08 w=4.0000000000000003e-07
MP1593 inv_1592 xor_1587 VDD VDD PMOS l=6.000000000000001e-08 w=4.0000000000000003e-07
MN1594 inv_1592 xor_1587 0 0 NMOS l=6.000000000000001e-08 w=2.0000000000000002e-07
MP1596 inv_1595 cout_1576 VDD VDD PMOS l=6.000000000000001e-08 w=4.0000000000000003e-07
MN1597 inv_1595 cout_1576 0 0 NMOS l=6.000000000000001e-08 w=2.0000000000000002e-07
MN1599 xor_1587 inv_1595 xor_1598 0 NMOS l=6.000000000000001e-08 w=2.0000000000000002e-07
MP1600 xor_1587 cout_1576 xor_1598 VDD PMOS l=6.000000000000001e-08 w=4.0000000000000003e-07
MN1601 inv_1592 cout_1576 xor_1598 0 NMOS l=6.000000000000001e-08 w=2.0000000000000002e-07
MP1602 inv_1592 inv_1595 xor_1598 VDD PMOS l=6.000000000000001e-08 w=4.0000000000000003e-07
MN1604 cout_1576 xor_1587 cout_1603 0 NMOS l=6.000000000000001e-08 w=2.0000000000000002e-07
MP1605 cout_1576 inv_1592 cout_1603 VDD PMOS l=6.000000000000001e-08 w=4.0000000000000003e-07
MN1606 Cin4_21 inv_1592 cout_1603 0 NMOS l=6.000000000000001e-08 w=2.0000000000000002e-07
MP1607 Cin4_21 xor_1587 cout_1603 VDD PMOS l=6.000000000000001e-08 w=4.0000000000000003e-07
MP1609 inv_1608 cout_1603 VDD VDD PMOS l=6.000000000000001e-08 w=4.0000000000000003e-07
MN1610 inv_1608 cout_1603 0 0 NMOS l=6.000000000000001e-08 w=2.0000000000000002e-07
MP1612 inv_1611 inv_1608 VDD VDD PMOS l=6.000000000000001e-08 w=4.0000000000000003e-07
MN1613 inv_1611 inv_1608 0 0 NMOS l=6.000000000000001e-08 w=2.0000000000000002e-07
MP1615 inv_1614 Cin5_22 VDD VDD PMOS l=6.000000000000001e-08 w=4.0000000000000003e-07
MN1616 inv_1614 Cin5_22 0 0 NMOS l=6.000000000000001e-08 w=2.0000000000000002e-07
MP1618 inv_1617 xor_1363 VDD VDD PMOS l=6.000000000000001e-08 w=4.0000000000000003e-07
MN1619 inv_1617 xor_1363 0 0 NMOS l=6.000000000000001e-08 w=2.0000000000000002e-07
MN1621 Cin5_22 inv_1617 xor_1620 0 NMOS l=6.000000000000001e-08 w=2.0000000000000002e-07
MP1622 Cin5_22 xor_1363 xor_1620 VDD PMOS l=6.000000000000001e-08 w=4.0000000000000003e-07
MN1623 inv_1614 xor_1363 xor_1620 0 NMOS l=6.000000000000001e-08 w=2.0000000000000002e-07
MP1624 inv_1614 inv_1617 xor_1620 VDD PMOS l=6.000000000000001e-08 w=4.0000000000000003e-07
MP1626 inv_1625 xor_1620 VDD VDD PMOS l=6.000000000000001e-08 w=4.0000000000000003e-07
MN1627 inv_1625 xor_1620 0 0 NMOS l=6.000000000000001e-08 w=2.0000000000000002e-07
MP1629 inv_1628 inv_1611 VDD VDD PMOS l=6.000000000000001e-08 w=4.0000000000000003e-07
MN1630 inv_1628 inv_1611 0 0 NMOS l=6.000000000000001e-08 w=2.0000000000000002e-07
MN1632 xor_1620 inv_1628 xor_1631 0 NMOS l=6.000000000000001e-08 w=2.0000000000000002e-07
MP1633 xor_1620 inv_1611 xor_1631 VDD PMOS l=6.000000000000001e-08 w=4.0000000000000003e-07
MN1634 inv_1625 inv_1611 xor_1631 0 NMOS l=6.000000000000001e-08 w=2.0000000000000002e-07
MP1635 inv_1625 inv_1628 xor_1631 VDD PMOS l=6.000000000000001e-08 w=4.0000000000000003e-07
MN1637 inv_1611 xor_1620 cout_1636 0 NMOS l=6.000000000000001e-08 w=2.0000000000000002e-07
MP1638 inv_1611 inv_1625 cout_1636 VDD PMOS l=6.000000000000001e-08 w=4.0000000000000003e-07
MN1639 Cin5_22 inv_1625 cout_1636 0 NMOS l=6.000000000000001e-08 w=2.0000000000000002e-07
MP1640 Cin5_22 xor_1620 cout_1636 VDD PMOS l=6.000000000000001e-08 w=4.0000000000000003e-07
MP1642 inv_1641 Cin6_23 VDD VDD PMOS l=6.000000000000001e-08 w=4.0000000000000003e-07
MN1643 inv_1641 Cin6_23 0 0 NMOS l=6.000000000000001e-08 w=2.0000000000000002e-07
MP1645 inv_1644 xor_1374 VDD VDD PMOS l=6.000000000000001e-08 w=4.0000000000000003e-07
MN1646 inv_1644 xor_1374 0 0 NMOS l=6.000000000000001e-08 w=2.0000000000000002e-07
MN1648 Cin6_23 inv_1644 xor_1647 0 NMOS l=6.000000000000001e-08 w=2.0000000000000002e-07
MP1649 Cin6_23 xor_1374 xor_1647 VDD PMOS l=6.000000000000001e-08 w=4.0000000000000003e-07
MN1650 inv_1641 xor_1374 xor_1647 0 NMOS l=6.000000000000001e-08 w=2.0000000000000002e-07
MP1651 inv_1641 inv_1644 xor_1647 VDD PMOS l=6.000000000000001e-08 w=4.0000000000000003e-07
MP1653 inv_1652 xor_1647 VDD VDD PMOS l=6.000000000000001e-08 w=4.0000000000000003e-07
MN1654 inv_1652 xor_1647 0 0 NMOS l=6.000000000000001e-08 w=2.0000000000000002e-07
MP1656 inv_1655 cout_1636 VDD VDD PMOS l=6.000000000000001e-08 w=4.0000000000000003e-07
MN1657 inv_1655 cout_1636 0 0 NMOS l=6.000000000000001e-08 w=2.0000000000000002e-07
MN1659 xor_1647 inv_1655 xor_1658 0 NMOS l=6.000000000000001e-08 w=2.0000000000000002e-07
MP1660 xor_1647 cout_1636 xor_1658 VDD PMOS l=6.000000000000001e-08 w=4.0000000000000003e-07
MN1661 inv_1652 cout_1636 xor_1658 0 NMOS l=6.000000000000001e-08 w=2.0000000000000002e-07
MP1662 inv_1652 inv_1655 xor_1658 VDD PMOS l=6.000000000000001e-08 w=4.0000000000000003e-07
MN1664 cout_1636 xor_1647 cout_1663 0 NMOS l=6.000000000000001e-08 w=2.0000000000000002e-07
MP1665 cout_1636 inv_1652 cout_1663 VDD PMOS l=6.000000000000001e-08 w=4.0000000000000003e-07
MN1666 Cin6_23 inv_1652 cout_1663 0 NMOS l=6.000000000000001e-08 w=2.0000000000000002e-07
MP1667 Cin6_23 xor_1647 cout_1663 VDD PMOS l=6.000000000000001e-08 w=4.0000000000000003e-07
MP1669 inv_1668 Cin7_24 VDD VDD PMOS l=6.000000000000001e-08 w=4.0000000000000003e-07
MN1670 inv_1668 Cin7_24 0 0 NMOS l=6.000000000000001e-08 w=2.0000000000000002e-07
MP1672 inv_1671 xor_1385 VDD VDD PMOS l=6.000000000000001e-08 w=4.0000000000000003e-07
MN1673 inv_1671 xor_1385 0 0 NMOS l=6.000000000000001e-08 w=2.0000000000000002e-07
MN1675 Cin7_24 inv_1671 xor_1674 0 NMOS l=6.000000000000001e-08 w=2.0000000000000002e-07
MP1676 Cin7_24 xor_1385 xor_1674 VDD PMOS l=6.000000000000001e-08 w=4.0000000000000003e-07
MN1677 inv_1668 xor_1385 xor_1674 0 NMOS l=6.000000000000001e-08 w=2.0000000000000002e-07
MP1678 inv_1668 inv_1671 xor_1674 VDD PMOS l=6.000000000000001e-08 w=4.0000000000000003e-07
MP1680 inv_1679 xor_1674 VDD VDD PMOS l=6.000000000000001e-08 w=4.0000000000000003e-07
MN1681 inv_1679 xor_1674 0 0 NMOS l=6.000000000000001e-08 w=2.0000000000000002e-07
MP1683 inv_1682 cout_1663 VDD VDD PMOS l=6.000000000000001e-08 w=4.0000000000000003e-07
MN1684 inv_1682 cout_1663 0 0 NMOS l=6.000000000000001e-08 w=2.0000000000000002e-07
MN1686 xor_1674 inv_1682 xor_1685 0 NMOS l=6.000000000000001e-08 w=2.0000000000000002e-07
MP1687 xor_1674 cout_1663 xor_1685 VDD PMOS l=6.000000000000001e-08 w=4.0000000000000003e-07
MN1688 inv_1679 cout_1663 xor_1685 0 NMOS l=6.000000000000001e-08 w=2.0000000000000002e-07
MP1689 inv_1679 inv_1682 xor_1685 VDD PMOS l=6.000000000000001e-08 w=4.0000000000000003e-07
MN1691 cout_1663 xor_1674 cout_1690 0 NMOS l=6.000000000000001e-08 w=2.0000000000000002e-07
MP1692 cout_1663 inv_1679 cout_1690 VDD PMOS l=6.000000000000001e-08 w=4.0000000000000003e-07
MN1693 Cin7_24 inv_1679 cout_1690 0 NMOS l=6.000000000000001e-08 w=2.0000000000000002e-07
MP1694 Cin7_24 xor_1674 cout_1690 VDD PMOS l=6.000000000000001e-08 w=4.0000000000000003e-07
MP1696 inv_1695 Cin8_25 VDD VDD PMOS l=6.000000000000001e-08 w=4.0000000000000003e-07
MN1697 inv_1695 Cin8_25 0 0 NMOS l=6.000000000000001e-08 w=2.0000000000000002e-07
MP1699 inv_1698 xor_1396 VDD VDD PMOS l=6.000000000000001e-08 w=4.0000000000000003e-07
MN1700 inv_1698 xor_1396 0 0 NMOS l=6.000000000000001e-08 w=2.0000000000000002e-07
MN1702 Cin8_25 inv_1698 xor_1701 0 NMOS l=6.000000000000001e-08 w=2.0000000000000002e-07
MP1703 Cin8_25 xor_1396 xor_1701 VDD PMOS l=6.000000000000001e-08 w=4.0000000000000003e-07
MN1704 inv_1695 xor_1396 xor_1701 0 NMOS l=6.000000000000001e-08 w=2.0000000000000002e-07
MP1705 inv_1695 inv_1698 xor_1701 VDD PMOS l=6.000000000000001e-08 w=4.0000000000000003e-07
MP1707 inv_1706 xor_1701 VDD VDD PMOS l=6.000000000000001e-08 w=4.0000000000000003e-07
MN1708 inv_1706 xor_1701 0 0 NMOS l=6.000000000000001e-08 w=2.0000000000000002e-07
MP1710 inv_1709 cout_1690 VDD VDD PMOS l=6.000000000000001e-08 w=4.0000000000000003e-07
MN1711 inv_1709 cout_1690 0 0 NMOS l=6.000000000000001e-08 w=2.0000000000000002e-07
MN1713 xor_1701 inv_1709 xor_1712 0 NMOS l=6.000000000000001e-08 w=2.0000000000000002e-07
MP1714 xor_1701 cout_1690 xor_1712 VDD PMOS l=6.000000000000001e-08 w=4.0000000000000003e-07
MN1715 inv_1706 cout_1690 xor_1712 0 NMOS l=6.000000000000001e-08 w=2.0000000000000002e-07
MP1716 inv_1706 inv_1709 xor_1712 VDD PMOS l=6.000000000000001e-08 w=4.0000000000000003e-07
MN1718 cout_1690 xor_1701 cout_1717 0 NMOS l=6.000000000000001e-08 w=2.0000000000000002e-07
MP1719 cout_1690 inv_1706 cout_1717 VDD PMOS l=6.000000000000001e-08 w=4.0000000000000003e-07
MN1720 Cin8_25 inv_1706 cout_1717 0 NMOS l=6.000000000000001e-08 w=2.0000000000000002e-07
MP1721 Cin8_25 xor_1701 cout_1717 VDD PMOS l=6.000000000000001e-08 w=4.0000000000000003e-07
MP1723 inv_1722 cout_1717 VDD VDD PMOS l=6.000000000000001e-08 w=4.0000000000000003e-07
MN1724 inv_1722 cout_1717 0 0 NMOS l=6.000000000000001e-08 w=2.0000000000000002e-07
MP1726 inv_1725 inv_1722 VDD VDD PMOS l=6.000000000000001e-08 w=4.0000000000000003e-07
MN1727 inv_1725 inv_1722 0 0 NMOS l=6.000000000000001e-08 w=2.0000000000000002e-07
MP1729 inv_1728 Cin9_26 VDD VDD PMOS l=6.000000000000001e-08 w=4.0000000000000003e-07
MN1730 inv_1728 Cin9_26 0 0 NMOS l=6.000000000000001e-08 w=2.0000000000000002e-07
MP1732 inv_1731 xor_1407 VDD VDD PMOS l=6.000000000000001e-08 w=4.0000000000000003e-07
MN1733 inv_1731 xor_1407 0 0 NMOS l=6.000000000000001e-08 w=2.0000000000000002e-07
MN1735 Cin9_26 inv_1731 xor_1734 0 NMOS l=6.000000000000001e-08 w=2.0000000000000002e-07
MP1736 Cin9_26 xor_1407 xor_1734 VDD PMOS l=6.000000000000001e-08 w=4.0000000000000003e-07
MN1737 inv_1728 xor_1407 xor_1734 0 NMOS l=6.000000000000001e-08 w=2.0000000000000002e-07
MP1738 inv_1728 inv_1731 xor_1734 VDD PMOS l=6.000000000000001e-08 w=4.0000000000000003e-07
MP1740 inv_1739 xor_1734 VDD VDD PMOS l=6.000000000000001e-08 w=4.0000000000000003e-07
MN1741 inv_1739 xor_1734 0 0 NMOS l=6.000000000000001e-08 w=2.0000000000000002e-07
MP1743 inv_1742 inv_1725 VDD VDD PMOS l=6.000000000000001e-08 w=4.0000000000000003e-07
MN1744 inv_1742 inv_1725 0 0 NMOS l=6.000000000000001e-08 w=2.0000000000000002e-07
MN1746 xor_1734 inv_1742 xor_1745 0 NMOS l=6.000000000000001e-08 w=2.0000000000000002e-07
MP1747 xor_1734 inv_1725 xor_1745 VDD PMOS l=6.000000000000001e-08 w=4.0000000000000003e-07
MN1748 inv_1739 inv_1725 xor_1745 0 NMOS l=6.000000000000001e-08 w=2.0000000000000002e-07
MP1749 inv_1739 inv_1742 xor_1745 VDD PMOS l=6.000000000000001e-08 w=4.0000000000000003e-07
MN1751 inv_1725 xor_1734 cout_1750 0 NMOS l=6.000000000000001e-08 w=2.0000000000000002e-07
MP1752 inv_1725 inv_1739 cout_1750 VDD PMOS l=6.000000000000001e-08 w=4.0000000000000003e-07
MN1753 Cin9_26 inv_1739 cout_1750 0 NMOS l=6.000000000000001e-08 w=2.0000000000000002e-07
MP1754 Cin9_26 xor_1734 cout_1750 VDD PMOS l=6.000000000000001e-08 w=4.0000000000000003e-07
MP1756 inv_1755 Cin10_27 VDD VDD PMOS l=6.000000000000001e-08 w=4.0000000000000003e-07
MN1757 inv_1755 Cin10_27 0 0 NMOS l=6.000000000000001e-08 w=2.0000000000000002e-07
MP1759 inv_1758 xor_1418 VDD VDD PMOS l=6.000000000000001e-08 w=4.0000000000000003e-07
MN1760 inv_1758 xor_1418 0 0 NMOS l=6.000000000000001e-08 w=2.0000000000000002e-07
MN1762 Cin10_27 inv_1758 xor_1761 0 NMOS l=6.000000000000001e-08 w=2.0000000000000002e-07
MP1763 Cin10_27 xor_1418 xor_1761 VDD PMOS l=6.000000000000001e-08 w=4.0000000000000003e-07
MN1764 inv_1755 xor_1418 xor_1761 0 NMOS l=6.000000000000001e-08 w=2.0000000000000002e-07
MP1765 inv_1755 inv_1758 xor_1761 VDD PMOS l=6.000000000000001e-08 w=4.0000000000000003e-07
MP1767 inv_1766 xor_1761 VDD VDD PMOS l=6.000000000000001e-08 w=4.0000000000000003e-07
MN1768 inv_1766 xor_1761 0 0 NMOS l=6.000000000000001e-08 w=2.0000000000000002e-07
MP1770 inv_1769 cout_1750 VDD VDD PMOS l=6.000000000000001e-08 w=4.0000000000000003e-07
MN1771 inv_1769 cout_1750 0 0 NMOS l=6.000000000000001e-08 w=2.0000000000000002e-07
MN1773 xor_1761 inv_1769 xor_1772 0 NMOS l=6.000000000000001e-08 w=2.0000000000000002e-07
MP1774 xor_1761 cout_1750 xor_1772 VDD PMOS l=6.000000000000001e-08 w=4.0000000000000003e-07
MN1775 inv_1766 cout_1750 xor_1772 0 NMOS l=6.000000000000001e-08 w=2.0000000000000002e-07
MP1776 inv_1766 inv_1769 xor_1772 VDD PMOS l=6.000000000000001e-08 w=4.0000000000000003e-07
MN1778 cout_1750 xor_1761 cout_1777 0 NMOS l=6.000000000000001e-08 w=2.0000000000000002e-07
MP1779 cout_1750 inv_1766 cout_1777 VDD PMOS l=6.000000000000001e-08 w=4.0000000000000003e-07
MN1780 Cin10_27 inv_1766 cout_1777 0 NMOS l=6.000000000000001e-08 w=2.0000000000000002e-07
MP1781 Cin10_27 xor_1761 cout_1777 VDD PMOS l=6.000000000000001e-08 w=4.0000000000000003e-07
MP1783 inv_1782 Cin11_28 VDD VDD PMOS l=6.000000000000001e-08 w=4.0000000000000003e-07
MN1784 inv_1782 Cin11_28 0 0 NMOS l=6.000000000000001e-08 w=2.0000000000000002e-07
MP1786 inv_1785 xor_1429 VDD VDD PMOS l=6.000000000000001e-08 w=4.0000000000000003e-07
MN1787 inv_1785 xor_1429 0 0 NMOS l=6.000000000000001e-08 w=2.0000000000000002e-07
MN1789 Cin11_28 inv_1785 xor_1788 0 NMOS l=6.000000000000001e-08 w=2.0000000000000002e-07
MP1790 Cin11_28 xor_1429 xor_1788 VDD PMOS l=6.000000000000001e-08 w=4.0000000000000003e-07
MN1791 inv_1782 xor_1429 xor_1788 0 NMOS l=6.000000000000001e-08 w=2.0000000000000002e-07
MP1792 inv_1782 inv_1785 xor_1788 VDD PMOS l=6.000000000000001e-08 w=4.0000000000000003e-07
MP1794 inv_1793 xor_1788 VDD VDD PMOS l=6.000000000000001e-08 w=4.0000000000000003e-07
MN1795 inv_1793 xor_1788 0 0 NMOS l=6.000000000000001e-08 w=2.0000000000000002e-07
MP1797 inv_1796 cout_1777 VDD VDD PMOS l=6.000000000000001e-08 w=4.0000000000000003e-07
MN1798 inv_1796 cout_1777 0 0 NMOS l=6.000000000000001e-08 w=2.0000000000000002e-07
MN1800 xor_1788 inv_1796 xor_1799 0 NMOS l=6.000000000000001e-08 w=2.0000000000000002e-07
MP1801 xor_1788 cout_1777 xor_1799 VDD PMOS l=6.000000000000001e-08 w=4.0000000000000003e-07
MN1802 inv_1793 cout_1777 xor_1799 0 NMOS l=6.000000000000001e-08 w=2.0000000000000002e-07
MP1803 inv_1793 inv_1796 xor_1799 VDD PMOS l=6.000000000000001e-08 w=4.0000000000000003e-07
MN1805 cout_1777 xor_1788 cout_1804 0 NMOS l=6.000000000000001e-08 w=2.0000000000000002e-07
MP1806 cout_1777 inv_1793 cout_1804 VDD PMOS l=6.000000000000001e-08 w=4.0000000000000003e-07
MN1807 Cin11_28 inv_1793 cout_1804 0 NMOS l=6.000000000000001e-08 w=2.0000000000000002e-07
MP1808 Cin11_28 xor_1788 cout_1804 VDD PMOS l=6.000000000000001e-08 w=4.0000000000000003e-07
MP1810 inv_1809 Cin12_29 VDD VDD PMOS l=6.000000000000001e-08 w=4.0000000000000003e-07
MN1811 inv_1809 Cin12_29 0 0 NMOS l=6.000000000000001e-08 w=2.0000000000000002e-07
MP1813 inv_1812 xor_1440 VDD VDD PMOS l=6.000000000000001e-08 w=4.0000000000000003e-07
MN1814 inv_1812 xor_1440 0 0 NMOS l=6.000000000000001e-08 w=2.0000000000000002e-07
MN1816 Cin12_29 inv_1812 xor_1815 0 NMOS l=6.000000000000001e-08 w=2.0000000000000002e-07
MP1817 Cin12_29 xor_1440 xor_1815 VDD PMOS l=6.000000000000001e-08 w=4.0000000000000003e-07
MN1818 inv_1809 xor_1440 xor_1815 0 NMOS l=6.000000000000001e-08 w=2.0000000000000002e-07
MP1819 inv_1809 inv_1812 xor_1815 VDD PMOS l=6.000000000000001e-08 w=4.0000000000000003e-07
MP1821 inv_1820 xor_1815 VDD VDD PMOS l=6.000000000000001e-08 w=4.0000000000000003e-07
MN1822 inv_1820 xor_1815 0 0 NMOS l=6.000000000000001e-08 w=2.0000000000000002e-07
MP1824 inv_1823 cout_1804 VDD VDD PMOS l=6.000000000000001e-08 w=4.0000000000000003e-07
MN1825 inv_1823 cout_1804 0 0 NMOS l=6.000000000000001e-08 w=2.0000000000000002e-07
MN1827 xor_1815 inv_1823 xor_1826 0 NMOS l=6.000000000000001e-08 w=2.0000000000000002e-07
MP1828 xor_1815 cout_1804 xor_1826 VDD PMOS l=6.000000000000001e-08 w=4.0000000000000003e-07
MN1829 inv_1820 cout_1804 xor_1826 0 NMOS l=6.000000000000001e-08 w=2.0000000000000002e-07
MP1830 inv_1820 inv_1823 xor_1826 VDD PMOS l=6.000000000000001e-08 w=4.0000000000000003e-07
MN1832 cout_1804 xor_1815 cout_1831 0 NMOS l=6.000000000000001e-08 w=2.0000000000000002e-07
MP1833 cout_1804 inv_1820 cout_1831 VDD PMOS l=6.000000000000001e-08 w=4.0000000000000003e-07
MN1834 Cin12_29 inv_1820 cout_1831 0 NMOS l=6.000000000000001e-08 w=2.0000000000000002e-07
MP1835 Cin12_29 xor_1815 cout_1831 VDD PMOS l=6.000000000000001e-08 w=4.0000000000000003e-07
MP1837 inv_1836 cout_1831 VDD VDD PMOS l=6.000000000000001e-08 w=4.0000000000000003e-07
MN1838 inv_1836 cout_1831 0 0 NMOS l=6.000000000000001e-08 w=2.0000000000000002e-07
MP1840 inv_1839 inv_1836 VDD VDD PMOS l=6.000000000000001e-08 w=4.0000000000000003e-07
MN1841 inv_1839 inv_1836 0 0 NMOS l=6.000000000000001e-08 w=2.0000000000000002e-07
MP1843 inv_1842 Cin13_30 VDD VDD PMOS l=6.000000000000001e-08 w=4.0000000000000003e-07
MN1844 inv_1842 Cin13_30 0 0 NMOS l=6.000000000000001e-08 w=2.0000000000000002e-07
MP1846 inv_1845 xor_1451 VDD VDD PMOS l=6.000000000000001e-08 w=4.0000000000000003e-07
MN1847 inv_1845 xor_1451 0 0 NMOS l=6.000000000000001e-08 w=2.0000000000000002e-07
MN1849 Cin13_30 inv_1845 xor_1848 0 NMOS l=6.000000000000001e-08 w=2.0000000000000002e-07
MP1850 Cin13_30 xor_1451 xor_1848 VDD PMOS l=6.000000000000001e-08 w=4.0000000000000003e-07
MN1851 inv_1842 xor_1451 xor_1848 0 NMOS l=6.000000000000001e-08 w=2.0000000000000002e-07
MP1852 inv_1842 inv_1845 xor_1848 VDD PMOS l=6.000000000000001e-08 w=4.0000000000000003e-07
MP1854 inv_1853 xor_1848 VDD VDD PMOS l=6.000000000000001e-08 w=4.0000000000000003e-07
MN1855 inv_1853 xor_1848 0 0 NMOS l=6.000000000000001e-08 w=2.0000000000000002e-07
MP1857 inv_1856 inv_1839 VDD VDD PMOS l=6.000000000000001e-08 w=4.0000000000000003e-07
MN1858 inv_1856 inv_1839 0 0 NMOS l=6.000000000000001e-08 w=2.0000000000000002e-07
MN1860 xor_1848 inv_1856 xor_1859 0 NMOS l=6.000000000000001e-08 w=2.0000000000000002e-07
MP1861 xor_1848 inv_1839 xor_1859 VDD PMOS l=6.000000000000001e-08 w=4.0000000000000003e-07
MN1862 inv_1853 inv_1839 xor_1859 0 NMOS l=6.000000000000001e-08 w=2.0000000000000002e-07
MP1863 inv_1853 inv_1856 xor_1859 VDD PMOS l=6.000000000000001e-08 w=4.0000000000000003e-07
MN1865 inv_1839 xor_1848 cout_1864 0 NMOS l=6.000000000000001e-08 w=2.0000000000000002e-07
MP1866 inv_1839 inv_1853 cout_1864 VDD PMOS l=6.000000000000001e-08 w=4.0000000000000003e-07
MN1867 Cin13_30 inv_1853 cout_1864 0 NMOS l=6.000000000000001e-08 w=2.0000000000000002e-07
MP1868 Cin13_30 xor_1848 cout_1864 VDD PMOS l=6.000000000000001e-08 w=4.0000000000000003e-07
MP1870 inv_1869 Cin14_31 VDD VDD PMOS l=6.000000000000001e-08 w=4.0000000000000003e-07
MN1871 inv_1869 Cin14_31 0 0 NMOS l=6.000000000000001e-08 w=2.0000000000000002e-07
MP1873 inv_1872 xor_1462 VDD VDD PMOS l=6.000000000000001e-08 w=4.0000000000000003e-07
MN1874 inv_1872 xor_1462 0 0 NMOS l=6.000000000000001e-08 w=2.0000000000000002e-07
MN1876 Cin14_31 inv_1872 xor_1875 0 NMOS l=6.000000000000001e-08 w=2.0000000000000002e-07
MP1877 Cin14_31 xor_1462 xor_1875 VDD PMOS l=6.000000000000001e-08 w=4.0000000000000003e-07
MN1878 inv_1869 xor_1462 xor_1875 0 NMOS l=6.000000000000001e-08 w=2.0000000000000002e-07
MP1879 inv_1869 inv_1872 xor_1875 VDD PMOS l=6.000000000000001e-08 w=4.0000000000000003e-07
MP1881 inv_1880 xor_1875 VDD VDD PMOS l=6.000000000000001e-08 w=4.0000000000000003e-07
MN1882 inv_1880 xor_1875 0 0 NMOS l=6.000000000000001e-08 w=2.0000000000000002e-07
MP1884 inv_1883 cout_1864 VDD VDD PMOS l=6.000000000000001e-08 w=4.0000000000000003e-07
MN1885 inv_1883 cout_1864 0 0 NMOS l=6.000000000000001e-08 w=2.0000000000000002e-07
MN1887 xor_1875 inv_1883 xor_1886 0 NMOS l=6.000000000000001e-08 w=2.0000000000000002e-07
MP1888 xor_1875 cout_1864 xor_1886 VDD PMOS l=6.000000000000001e-08 w=4.0000000000000003e-07
MN1889 inv_1880 cout_1864 xor_1886 0 NMOS l=6.000000000000001e-08 w=2.0000000000000002e-07
MP1890 inv_1880 inv_1883 xor_1886 VDD PMOS l=6.000000000000001e-08 w=4.0000000000000003e-07
MN1892 cout_1864 xor_1875 cout_1891 0 NMOS l=6.000000000000001e-08 w=2.0000000000000002e-07
MP1893 cout_1864 inv_1880 cout_1891 VDD PMOS l=6.000000000000001e-08 w=4.0000000000000003e-07
MN1894 Cin14_31 inv_1880 cout_1891 0 NMOS l=6.000000000000001e-08 w=2.0000000000000002e-07
MP1895 Cin14_31 xor_1875 cout_1891 VDD PMOS l=6.000000000000001e-08 w=4.0000000000000003e-07
MP1897 inv_1896 Cin15_32 VDD VDD PMOS l=6.000000000000001e-08 w=4.0000000000000003e-07
MN1898 inv_1896 Cin15_32 0 0 NMOS l=6.000000000000001e-08 w=2.0000000000000002e-07
MP1900 inv_1899 xor_192 VDD VDD PMOS l=6.000000000000001e-08 w=4.0000000000000003e-07
MN1901 inv_1899 xor_192 0 0 NMOS l=6.000000000000001e-08 w=2.0000000000000002e-07
MN1903 Cin15_32 inv_1899 xor_1902 0 NMOS l=6.000000000000001e-08 w=2.0000000000000002e-07
MP1904 Cin15_32 xor_192 xor_1902 VDD PMOS l=6.000000000000001e-08 w=4.0000000000000003e-07
MN1905 inv_1896 xor_192 xor_1902 0 NMOS l=6.000000000000001e-08 w=2.0000000000000002e-07
MP1906 inv_1896 inv_1899 xor_1902 VDD PMOS l=6.000000000000001e-08 w=4.0000000000000003e-07
MP1908 inv_1907 xor_1902 VDD VDD PMOS l=6.000000000000001e-08 w=4.0000000000000003e-07
MN1909 inv_1907 xor_1902 0 0 NMOS l=6.000000000000001e-08 w=2.0000000000000002e-07
MP1911 inv_1910 cout_1891 VDD VDD PMOS l=6.000000000000001e-08 w=4.0000000000000003e-07
MN1912 inv_1910 cout_1891 0 0 NMOS l=6.000000000000001e-08 w=2.0000000000000002e-07
MN1914 xor_1902 inv_1910 xor_1913 0 NMOS l=6.000000000000001e-08 w=2.0000000000000002e-07
MP1915 xor_1902 cout_1891 xor_1913 VDD PMOS l=6.000000000000001e-08 w=4.0000000000000003e-07
MN1916 inv_1907 cout_1891 xor_1913 0 NMOS l=6.000000000000001e-08 w=2.0000000000000002e-07
MP1917 inv_1907 inv_1910 xor_1913 VDD PMOS l=6.000000000000001e-08 w=4.0000000000000003e-07
MN1919 cout_1891 xor_1902 cout_1918 0 NMOS l=6.000000000000001e-08 w=2.0000000000000002e-07
MP1920 cout_1891 inv_1907 cout_1918 VDD PMOS l=6.000000000000001e-08 w=4.0000000000000003e-07
MN1921 Cin15_32 inv_1907 cout_1918 0 NMOS l=6.000000000000001e-08 w=2.0000000000000002e-07
MP1922 Cin15_32 xor_1902 cout_1918 VDD PMOS l=6.000000000000001e-08 w=4.0000000000000003e-07
MP1925 inv_1924 cout_1918 VDD VDD PMOS l=6.000000000000001e-08 w=4.0000000000000003e-07
MN1926 inv_1924 cout_1918 0 0 NMOS l=6.000000000000001e-08 w=2.0000000000000002e-07
MP1928 inv_1927 cout_1891 VDD VDD PMOS l=6.000000000000001e-08 w=4.0000000000000003e-07
MN1929 inv_1927 cout_1891 0 0 NMOS l=6.000000000000001e-08 w=2.0000000000000002e-07
MN1930 cout_1918 inv_1927 xor_1923 0 NMOS l=6.000000000000001e-08 w=2.0000000000000002e-07
MP1931 cout_1918 cout_1891 xor_1923 VDD PMOS l=6.000000000000001e-08 w=4.0000000000000003e-07
MN1932 inv_1924 cout_1891 xor_1923 0 NMOS l=6.000000000000001e-08 w=2.0000000000000002e-07
MP1933 inv_1924 inv_1927 xor_1923 VDD PMOS l=6.000000000000001e-08 w=4.0000000000000003e-07
MP1935 nand_1934 xor_1923 VDD VDD PMOS l=6.000000000000001e-08 w=4.0000000000000003e-07
MP1936 nand_1934 xor_1913 VDD VDD PMOS l=6.000000000000001e-08 w=4.0000000000000003e-07
MN1938 nand_1934 xor_1923 nd_1937 0 NMOS l=6.000000000000001e-08 w=2.0000000000000002e-07
MN1939 nd_1937 xor_1913 0 0 NMOS l=6.000000000000001e-08 w=2.0000000000000002e-07
MP1941 inv_1940 nand_1934 VDD VDD PMOS l=6.000000000000001e-08 w=4.0000000000000003e-07
MN1942 inv_1940 nand_1934 0 0 NMOS l=6.000000000000001e-08 w=2.0000000000000002e-07
MP1944 inv_1943 xor_1913 VDD VDD PMOS l=6.000000000000001e-08 w=4.0000000000000003e-07
MN1945 inv_1943 xor_1913 0 0 NMOS l=6.000000000000001e-08 w=2.0000000000000002e-07
MP1947 nand_1946 xor_1923 VDD VDD PMOS l=6.000000000000001e-08 w=4.0000000000000003e-07
MP1948 nand_1946 inv_1943 VDD VDD PMOS l=6.000000000000001e-08 w=4.0000000000000003e-07
MN1950 nand_1946 xor_1923 nd_1949 0 NMOS l=6.000000000000001e-08 w=2.0000000000000002e-07
MN1951 nd_1949 inv_1943 0 0 NMOS l=6.000000000000001e-08 w=2.0000000000000002e-07
MP1953 inv_1952 nand_1946 VDD VDD PMOS l=6.000000000000001e-08 w=4.0000000000000003e-07
MN1954 inv_1952 nand_1946 0 0 NMOS l=6.000000000000001e-08 w=2.0000000000000002e-07
MP1956 inv_1955 xor_1923 VDD VDD PMOS l=6.000000000000001e-08 w=4.0000000000000003e-07
MN1957 inv_1955 xor_1923 0 0 NMOS l=6.000000000000001e-08 w=2.0000000000000002e-07
MN1959 xor_1490 inv_1955 mux_1958 0 NMOS l=6.000000000000001e-08 w=2.0000000000000002e-07
MP1960 xor_1490 xor_1923 mux_1958 VDD PMOS l=6.000000000000001e-08 w=4.0000000000000003e-07
MN1961 inv_1940 xor_1923 mux_1958 0 NMOS l=6.000000000000001e-08 w=2.0000000000000002e-07
MP1962 inv_1940 inv_1955 mux_1958 VDD PMOS l=6.000000000000001e-08 w=4.0000000000000003e-07
MN1964 xor_1517 inv_1955 mux_1963 0 NMOS l=6.000000000000001e-08 w=2.0000000000000002e-07
MP1965 xor_1517 xor_1923 mux_1963 VDD PMOS l=6.000000000000001e-08 w=4.0000000000000003e-07
MN1966 inv_1940 xor_1923 mux_1963 0 NMOS l=6.000000000000001e-08 w=2.0000000000000002e-07
MP1967 inv_1940 inv_1955 mux_1963 VDD PMOS l=6.000000000000001e-08 w=4.0000000000000003e-07
MN1969 xor_1544 inv_1955 mux_1968 0 NMOS l=6.000000000000001e-08 w=2.0000000000000002e-07
MP1970 xor_1544 xor_1923 mux_1968 VDD PMOS l=6.000000000000001e-08 w=4.0000000000000003e-07
MN1971 inv_1940 xor_1923 mux_1968 0 NMOS l=6.000000000000001e-08 w=2.0000000000000002e-07
MP1972 inv_1940 inv_1955 mux_1968 VDD PMOS l=6.000000000000001e-08 w=4.0000000000000003e-07
MN1974 xor_1571 inv_1955 mux_1973 0 NMOS l=6.000000000000001e-08 w=2.0000000000000002e-07
MP1975 xor_1571 xor_1923 mux_1973 VDD PMOS l=6.000000000000001e-08 w=4.0000000000000003e-07
MN1976 inv_1940 xor_1923 mux_1973 0 NMOS l=6.000000000000001e-08 w=2.0000000000000002e-07
MP1977 inv_1940 inv_1955 mux_1973 VDD PMOS l=6.000000000000001e-08 w=4.0000000000000003e-07
MN1979 xor_1598 inv_1955 mux_1978 0 NMOS l=6.000000000000001e-08 w=2.0000000000000002e-07
MP1980 xor_1598 xor_1923 mux_1978 VDD PMOS l=6.000000000000001e-08 w=4.0000000000000003e-07
MN1981 inv_1940 xor_1923 mux_1978 0 NMOS l=6.000000000000001e-08 w=2.0000000000000002e-07
MP1982 inv_1940 inv_1955 mux_1978 VDD PMOS l=6.000000000000001e-08 w=4.0000000000000003e-07
MN1984 xor_1631 inv_1955 mux_1983 0 NMOS l=6.000000000000001e-08 w=2.0000000000000002e-07
MP1985 xor_1631 xor_1923 mux_1983 VDD PMOS l=6.000000000000001e-08 w=4.0000000000000003e-07
MN1986 inv_1940 xor_1923 mux_1983 0 NMOS l=6.000000000000001e-08 w=2.0000000000000002e-07
MP1987 inv_1940 inv_1955 mux_1983 VDD PMOS l=6.000000000000001e-08 w=4.0000000000000003e-07
MN1989 xor_1658 inv_1955 mux_1988 0 NMOS l=6.000000000000001e-08 w=2.0000000000000002e-07
MP1990 xor_1658 xor_1923 mux_1988 VDD PMOS l=6.000000000000001e-08 w=4.0000000000000003e-07
MN1991 inv_1940 xor_1923 mux_1988 0 NMOS l=6.000000000000001e-08 w=2.0000000000000002e-07
MP1992 inv_1940 inv_1955 mux_1988 VDD PMOS l=6.000000000000001e-08 w=4.0000000000000003e-07
MN1994 xor_1685 inv_1955 mux_1993 0 NMOS l=6.000000000000001e-08 w=2.0000000000000002e-07
MP1995 xor_1685 xor_1923 mux_1993 VDD PMOS l=6.000000000000001e-08 w=4.0000000000000003e-07
MN1996 inv_1940 xor_1923 mux_1993 0 NMOS l=6.000000000000001e-08 w=2.0000000000000002e-07
MP1997 inv_1940 inv_1955 mux_1993 VDD PMOS l=6.000000000000001e-08 w=4.0000000000000003e-07
MN1999 xor_1712 inv_1955 mux_1998 0 NMOS l=6.000000000000001e-08 w=2.0000000000000002e-07
MP2000 xor_1712 xor_1923 mux_1998 VDD PMOS l=6.000000000000001e-08 w=4.0000000000000003e-07
MN2001 inv_1940 xor_1923 mux_1998 0 NMOS l=6.000000000000001e-08 w=2.0000000000000002e-07
MP2002 inv_1940 inv_1955 mux_1998 VDD PMOS l=6.000000000000001e-08 w=4.0000000000000003e-07
MN2004 xor_1745 inv_1955 mux_2003 0 NMOS l=6.000000000000001e-08 w=2.0000000000000002e-07
MP2005 xor_1745 xor_1923 mux_2003 VDD PMOS l=6.000000000000001e-08 w=4.0000000000000003e-07
MN2006 inv_1940 xor_1923 mux_2003 0 NMOS l=6.000000000000001e-08 w=2.0000000000000002e-07
MP2007 inv_1940 inv_1955 mux_2003 VDD PMOS l=6.000000000000001e-08 w=4.0000000000000003e-07
MN2009 xor_1772 inv_1955 mux_2008 0 NMOS l=6.000000000000001e-08 w=2.0000000000000002e-07
MP2010 xor_1772 xor_1923 mux_2008 VDD PMOS l=6.000000000000001e-08 w=4.0000000000000003e-07
MN2011 inv_1940 xor_1923 mux_2008 0 NMOS l=6.000000000000001e-08 w=2.0000000000000002e-07
MP2012 inv_1940 inv_1955 mux_2008 VDD PMOS l=6.000000000000001e-08 w=4.0000000000000003e-07
MN2014 xor_1799 inv_1955 mux_2013 0 NMOS l=6.000000000000001e-08 w=2.0000000000000002e-07
MP2015 xor_1799 xor_1923 mux_2013 VDD PMOS l=6.000000000000001e-08 w=4.0000000000000003e-07
MN2016 inv_1940 xor_1923 mux_2013 0 NMOS l=6.000000000000001e-08 w=2.0000000000000002e-07
MP2017 inv_1940 inv_1955 mux_2013 VDD PMOS l=6.000000000000001e-08 w=4.0000000000000003e-07
MN2019 xor_1826 inv_1955 mux_2018 0 NMOS l=6.000000000000001e-08 w=2.0000000000000002e-07
MP2020 xor_1826 xor_1923 mux_2018 VDD PMOS l=6.000000000000001e-08 w=4.0000000000000003e-07
MN2021 inv_1940 xor_1923 mux_2018 0 NMOS l=6.000000000000001e-08 w=2.0000000000000002e-07
MP2022 inv_1940 inv_1955 mux_2018 VDD PMOS l=6.000000000000001e-08 w=4.0000000000000003e-07
MN2024 xor_1859 inv_1955 mux_2023 0 NMOS l=6.000000000000001e-08 w=2.0000000000000002e-07
MP2025 xor_1859 xor_1923 mux_2023 VDD PMOS l=6.000000000000001e-08 w=4.0000000000000003e-07
MN2026 inv_1940 xor_1923 mux_2023 0 NMOS l=6.000000000000001e-08 w=2.0000000000000002e-07
MP2027 inv_1940 inv_1955 mux_2023 VDD PMOS l=6.000000000000001e-08 w=4.0000000000000003e-07
MN2029 xor_1886 inv_1955 mux_2028 0 NMOS l=6.000000000000001e-08 w=2.0000000000000002e-07
MP2030 xor_1886 xor_1923 mux_2028 VDD PMOS l=6.000000000000001e-08 w=4.0000000000000003e-07
MN2031 inv_1940 xor_1923 mux_2028 0 NMOS l=6.000000000000001e-08 w=2.0000000000000002e-07
MP2032 inv_1940 inv_1955 mux_2028 VDD PMOS l=6.000000000000001e-08 w=4.0000000000000003e-07
MP2034 inv_2033 xor_1913 VDD VDD PMOS l=6.000000000000001e-08 w=4.0000000000000003e-07
MN2035 inv_2033 xor_1913 0 0 NMOS l=6.000000000000001e-08 w=2.0000000000000002e-07
MN2037 xor_1913 inv_1955 mux_2036 0 NMOS l=6.000000000000001e-08 w=2.0000000000000002e-07
MP2038 xor_1913 xor_1923 mux_2036 VDD PMOS l=6.000000000000001e-08 w=4.0000000000000003e-07
MN2039 inv_2033 xor_1923 mux_2036 0 NMOS l=6.000000000000001e-08 w=2.0000000000000002e-07
MP2040 inv_2033 inv_1955 mux_2036 VDD PMOS l=6.000000000000001e-08 w=4.0000000000000003e-07
