* Generated via PySpice Circuit object
.title FP8_MAC
* --- generic low-voltage CMOS (educational). Replace with a foundry BSIM4 ---
* --- card (.include 65nm_bulk.pm) for sign-off; W/L already in the M lines. -
.model NMOS NMOS (LEVEL=1 VTO=0.35  KP=300u GAMMA=0.40 PHI=0.90 LAMBDA=0.10
+                 CGSO=0.15n CGDO=0.15n CJ=1.0m CJSW=0.2n)
.model PMOS PMOS (LEVEL=1 VTO=-0.35 KP=90u  GAMMA=0.45 PHI=0.90 LAMBDA=0.12
+                 CGSO=0.15n CGDO=0.15n CJ=1.0m CJSW=0.2n)
VVDD VDD 0 1.0
MP37 nor4_33 A3_4 nu_34 VDD PMOS l=6.000000000000001e-08 w=4.0000000000000003e-07
MP38 nu_34 A4_5 nu_35 VDD PMOS l=6.000000000000001e-08 w=4.0000000000000003e-07
MP39 nu_35 A5_6 nu_36 VDD PMOS l=6.000000000000001e-08 w=4.0000000000000003e-07
MP40 nu_36 A6_7 VDD VDD PMOS l=6.000000000000001e-08 w=4.0000000000000003e-07
MN41 nor4_33 A3_4 0 0 NMOS l=6.000000000000001e-08 w=2.0000000000000002e-07
MN42 nor4_33 A4_5 0 0 NMOS l=6.000000000000001e-08 w=2.0000000000000002e-07
MN43 nor4_33 A5_6 0 0 NMOS l=6.000000000000001e-08 w=2.0000000000000002e-07
MN44 nor4_33 A6_7 0 0 NMOS l=6.000000000000001e-08 w=2.0000000000000002e-07
MP46 nand_45 A3_4 VDD VDD PMOS l=6.000000000000001e-08 w=4.0000000000000003e-07
MP47 nand_45 A4_5 VDD VDD PMOS l=6.000000000000001e-08 w=4.0000000000000003e-07
MN49 nand_45 A3_4 nd_48 0 NMOS l=6.000000000000001e-08 w=2.0000000000000002e-07
MN50 nd_48 A4_5 0 0 NMOS l=6.000000000000001e-08 w=2.0000000000000002e-07
MP52 inv_51 nand_45 VDD VDD PMOS l=6.000000000000001e-08 w=4.0000000000000003e-07
MN53 inv_51 nand_45 0 0 NMOS l=6.000000000000001e-08 w=2.0000000000000002e-07
MP55 nand_54 A5_6 VDD VDD PMOS l=6.000000000000001e-08 w=4.0000000000000003e-07
MP56 nand_54 A6_7 VDD VDD PMOS l=6.000000000000001e-08 w=4.0000000000000003e-07
MN58 nand_54 A5_6 nd_57 0 NMOS l=6.000000000000001e-08 w=2.0000000000000002e-07
MN59 nd_57 A6_7 0 0 NMOS l=6.000000000000001e-08 w=2.0000000000000002e-07
MP61 inv_60 nand_54 VDD VDD PMOS l=6.000000000000001e-08 w=4.0000000000000003e-07
MN62 inv_60 nand_54 0 0 NMOS l=6.000000000000001e-08 w=2.0000000000000002e-07
MP64 nand_63 inv_51 VDD VDD PMOS l=6.000000000000001e-08 w=4.0000000000000003e-07
MP65 nand_63 inv_60 VDD VDD PMOS l=6.000000000000001e-08 w=4.0000000000000003e-07
MN67 nand_63 inv_51 nd_66 0 NMOS l=6.000000000000001e-08 w=2.0000000000000002e-07
MN68 nd_66 inv_60 0 0 NMOS l=6.000000000000001e-08 w=2.0000000000000002e-07
MP70 inv_69 nand_63 VDD VDD PMOS l=6.000000000000001e-08 w=4.0000000000000003e-07
MN71 inv_69 nand_63 0 0 NMOS l=6.000000000000001e-08 w=2.0000000000000002e-07
MP73 nand_72 A0_1 VDD VDD PMOS l=6.000000000000001e-08 w=4.0000000000000003e-07
MP74 nand_72 A1_2 VDD VDD PMOS l=6.000000000000001e-08 w=4.0000000000000003e-07
MN76 nand_72 A0_1 nd_75 0 NMOS l=6.000000000000001e-08 w=2.0000000000000002e-07
MN77 nd_75 A1_2 0 0 NMOS l=6.000000000000001e-08 w=2.0000000000000002e-07
MP79 inv_78 nand_72 VDD VDD PMOS l=6.000000000000001e-08 w=4.0000000000000003e-07
MN80 inv_78 nand_72 0 0 NMOS l=6.000000000000001e-08 w=2.0000000000000002e-07
MP82 nand_81 inv_78 VDD VDD PMOS l=6.000000000000001e-08 w=4.0000000000000003e-07
MP83 nand_81 A2_3 VDD VDD PMOS l=6.000000000000001e-08 w=4.0000000000000003e-07
MN85 nand_81 inv_78 nd_84 0 NMOS l=6.000000000000001e-08 w=2.0000000000000002e-07
MN86 nd_84 A2_3 0 0 NMOS l=6.000000000000001e-08 w=2.0000000000000002e-07
MP88 inv_87 nand_81 VDD VDD PMOS l=6.000000000000001e-08 w=4.0000000000000003e-07
MN89 inv_87 nand_81 0 0 NMOS l=6.000000000000001e-08 w=2.0000000000000002e-07
MP91 nand_90 inv_69 VDD VDD PMOS l=6.000000000000001e-08 w=4.0000000000000003e-07
MP92 nand_90 inv_87 VDD VDD PMOS l=6.000000000000001e-08 w=4.0000000000000003e-07
MN94 nand_90 inv_69 nd_93 0 NMOS l=6.000000000000001e-08 w=2.0000000000000002e-07
MN95 nd_93 inv_87 0 0 NMOS l=6.000000000000001e-08 w=2.0000000000000002e-07
MP97 inv_96 nand_90 VDD VDD PMOS l=6.000000000000001e-08 w=4.0000000000000003e-07
MN98 inv_96 nand_90 0 0 NMOS l=6.000000000000001e-08 w=2.0000000000000002e-07
MP101 nor_99 nor4_33 nu_100 VDD PMOS l=6.000000000000001e-08 w=4.0000000000000003e-07
MP102 nu_100 inv_96 VDD VDD PMOS l=6.000000000000001e-08 w=4.0000000000000003e-07
MN103 nor_99 nor4_33 0 0 NMOS l=6.000000000000001e-08 w=2.0000000000000002e-07
MN104 nor_99 inv_96 0 0 NMOS l=6.000000000000001e-08 w=2.0000000000000002e-07
MP106 inv_105 nor_99 VDD VDD PMOS l=6.000000000000001e-08 w=4.0000000000000003e-07
MN107 inv_105 nor_99 0 0 NMOS l=6.000000000000001e-08 w=2.0000000000000002e-07
MP109 inv_108 inv_105 VDD VDD PMOS l=6.000000000000001e-08 w=4.0000000000000003e-07
MN110 inv_108 inv_105 0 0 NMOS l=6.000000000000001e-08 w=2.0000000000000002e-07
MP112 nand_111 A0_1 VDD VDD PMOS l=6.000000000000001e-08 w=4.0000000000000003e-07
MP113 nand_111 inv_108 VDD VDD PMOS l=6.000000000000001e-08 w=4.0000000000000003e-07
MN115 nand_111 A0_1 nd_114 0 NMOS l=6.000000000000001e-08 w=2.0000000000000002e-07
MN116 nd_114 inv_108 0 0 NMOS l=6.000000000000001e-08 w=2.0000000000000002e-07
MP118 inv_117 nand_111 VDD VDD PMOS l=6.000000000000001e-08 w=4.0000000000000003e-07
MN119 inv_117 nand_111 0 0 NMOS l=6.000000000000001e-08 w=2.0000000000000002e-07
MP121 nand_120 A1_2 VDD VDD PMOS l=6.000000000000001e-08 w=4.0000000000000003e-07
MP122 nand_120 inv_108 VDD VDD PMOS l=6.000000000000001e-08 w=4.0000000000000003e-07
MN124 nand_120 A1_2 nd_123 0 NMOS l=6.000000000000001e-08 w=2.0000000000000002e-07
MN125 nd_123 inv_108 0 0 NMOS l=6.000000000000001e-08 w=2.0000000000000002e-07
MP127 inv_126 nand_120 VDD VDD PMOS l=6.000000000000001e-08 w=4.0000000000000003e-07
MN128 inv_126 nand_120 0 0 NMOS l=6.000000000000001e-08 w=2.0000000000000002e-07
MP130 nand_129 A2_3 VDD VDD PMOS l=6.000000000000001e-08 w=4.0000000000000003e-07
MP131 nand_129 inv_108 VDD VDD PMOS l=6.000000000000001e-08 w=4.0000000000000003e-07
MN133 nand_129 A2_3 nd_132 0 NMOS l=6.000000000000001e-08 w=2.0000000000000002e-07
MN134 nd_132 inv_108 0 0 NMOS l=6.000000000000001e-08 w=2.0000000000000002e-07
MP136 inv_135 nand_129 VDD VDD PMOS l=6.000000000000001e-08 w=4.0000000000000003e-07
MN137 inv_135 nand_129 0 0 NMOS l=6.000000000000001e-08 w=2.0000000000000002e-07
MP142 nor4_138 B3_12 nu_139 VDD PMOS l=6.000000000000001e-08 w=4.0000000000000003e-07
MP143 nu_139 B4_13 nu_140 VDD PMOS l=6.000000000000001e-08 w=4.0000000000000003e-07
MP144 nu_140 B5_14 nu_141 VDD PMOS l=6.000000000000001e-08 w=4.0000000000000003e-07
MP145 nu_141 B6_15 VDD VDD PMOS l=6.000000000000001e-08 w=4.0000000000000003e-07
MN146 nor4_138 B3_12 0 0 NMOS l=6.000000000000001e-08 w=2.0000000000000002e-07
MN147 nor4_138 B4_13 0 0 NMOS l=6.000000000000001e-08 w=2.0000000000000002e-07
MN148 nor4_138 B5_14 0 0 NMOS l=6.000000000000001e-08 w=2.0000000000000002e-07
MN149 nor4_138 B6_15 0 0 NMOS l=6.000000000000001e-08 w=2.0000000000000002e-07
MP151 nand_150 B3_12 VDD VDD PMOS l=6.000000000000001e-08 w=4.0000000000000003e-07
MP152 nand_150 B4_13 VDD VDD PMOS l=6.000000000000001e-08 w=4.0000000000000003e-07
MN154 nand_150 B3_12 nd_153 0 NMOS l=6.000000000000001e-08 w=2.0000000000000002e-07
MN155 nd_153 B4_13 0 0 NMOS l=6.000000000000001e-08 w=2.0000000000000002e-07
MP157 inv_156 nand_150 VDD VDD PMOS l=6.000000000000001e-08 w=4.0000000000000003e-07
MN158 inv_156 nand_150 0 0 NMOS l=6.000000000000001e-08 w=2.0000000000000002e-07
MP160 nand_159 B5_14 VDD VDD PMOS l=6.000000000000001e-08 w=4.0000000000000003e-07
MP161 nand_159 B6_15 VDD VDD PMOS l=6.000000000000001e-08 w=4.0000000000000003e-07
MN163 nand_159 B5_14 nd_162 0 NMOS l=6.000000000000001e-08 w=2.0000000000000002e-07
MN164 nd_162 B6_15 0 0 NMOS l=6.000000000000001e-08 w=2.0000000000000002e-07
MP166 inv_165 nand_159 VDD VDD PMOS l=6.000000000000001e-08 w=4.0000000000000003e-07
MN167 inv_165 nand_159 0 0 NMOS l=6.000000000000001e-08 w=2.0000000000000002e-07
MP169 nand_168 inv_156 VDD VDD PMOS l=6.000000000000001e-08 w=4.0000000000000003e-07
MP170 nand_168 inv_165 VDD VDD PMOS l=6.000000000000001e-08 w=4.0000000000000003e-07
MN172 nand_168 inv_156 nd_171 0 NMOS l=6.000000000000001e-08 w=2.0000000000000002e-07
MN173 nd_171 inv_165 0 0 NMOS l=6.000000000000001e-08 w=2.0000000000000002e-07
MP175 inv_174 nand_168 VDD VDD PMOS l=6.000000000000001e-08 w=4.0000000000000003e-07
MN176 inv_174 nand_168 0 0 NMOS l=6.000000000000001e-08 w=2.0000000000000002e-07
MP178 nand_177 B0_9 VDD VDD PMOS l=6.000000000000001e-08 w=4.0000000000000003e-07
MP179 nand_177 B1_10 VDD VDD PMOS l=6.000000000000001e-08 w=4.0000000000000003e-07
MN181 nand_177 B0_9 nd_180 0 NMOS l=6.000000000000001e-08 w=2.0000000000000002e-07
MN182 nd_180 B1_10 0 0 NMOS l=6.000000000000001e-08 w=2.0000000000000002e-07
MP184 inv_183 nand_177 VDD VDD PMOS l=6.000000000000001e-08 w=4.0000000000000003e-07
MN185 inv_183 nand_177 0 0 NMOS l=6.000000000000001e-08 w=2.0000000000000002e-07
MP187 nand_186 inv_183 VDD VDD PMOS l=6.000000000000001e-08 w=4.0000000000000003e-07
MP188 nand_186 B2_11 VDD VDD PMOS l=6.000000000000001e-08 w=4.0000000000000003e-07
MN190 nand_186 inv_183 nd_189 0 NMOS l=6.000000000000001e-08 w=2.0000000000000002e-07
MN191 nd_189 B2_11 0 0 NMOS l=6.000000000000001e-08 w=2.0000000000000002e-07
MP193 inv_192 nand_186 VDD VDD PMOS l=6.000000000000001e-08 w=4.0000000000000003e-07
MN194 inv_192 nand_186 0 0 NMOS l=6.000000000000001e-08 w=2.0000000000000002e-07
MP196 nand_195 inv_174 VDD VDD PMOS l=6.000000000000001e-08 w=4.0000000000000003e-07
MP197 nand_195 inv_192 VDD VDD PMOS l=6.000000000000001e-08 w=4.0000000000000003e-07
MN199 nand_195 inv_174 nd_198 0 NMOS l=6.000000000000001e-08 w=2.0000000000000002e-07
MN200 nd_198 inv_192 0 0 NMOS l=6.000000000000001e-08 w=2.0000000000000002e-07
MP202 inv_201 nand_195 VDD VDD PMOS l=6.000000000000001e-08 w=4.0000000000000003e-07
MN203 inv_201 nand_195 0 0 NMOS l=6.000000000000001e-08 w=2.0000000000000002e-07
MP206 nor_204 nor4_138 nu_205 VDD PMOS l=6.000000000000001e-08 w=4.0000000000000003e-07
MP207 nu_205 inv_201 VDD VDD PMOS l=6.000000000000001e-08 w=4.0000000000000003e-07
MN208 nor_204 nor4_138 0 0 NMOS l=6.000000000000001e-08 w=2.0000000000000002e-07
MN209 nor_204 inv_201 0 0 NMOS l=6.000000000000001e-08 w=2.0000000000000002e-07
MP211 inv_210 nor_204 VDD VDD PMOS l=6.000000000000001e-08 w=4.0000000000000003e-07
MN212 inv_210 nor_204 0 0 NMOS l=6.000000000000001e-08 w=2.0000000000000002e-07
MP214 inv_213 inv_210 VDD VDD PMOS l=6.000000000000001e-08 w=4.0000000000000003e-07
MN215 inv_213 inv_210 0 0 NMOS l=6.000000000000001e-08 w=2.0000000000000002e-07
MP217 nand_216 B0_9 VDD VDD PMOS l=6.000000000000001e-08 w=4.0000000000000003e-07
MP218 nand_216 inv_213 VDD VDD PMOS l=6.000000000000001e-08 w=4.0000000000000003e-07
MN220 nand_216 B0_9 nd_219 0 NMOS l=6.000000000000001e-08 w=2.0000000000000002e-07
MN221 nd_219 inv_213 0 0 NMOS l=6.000000000000001e-08 w=2.0000000000000002e-07
MP223 inv_222 nand_216 VDD VDD PMOS l=6.000000000000001e-08 w=4.0000000000000003e-07
MN224 inv_222 nand_216 0 0 NMOS l=6.000000000000001e-08 w=2.0000000000000002e-07
MP226 nand_225 B1_10 VDD VDD PMOS l=6.000000000000001e-08 w=4.0000000000000003e-07
MP227 nand_225 inv_213 VDD VDD PMOS l=6.000000000000001e-08 w=4.0000000000000003e-07
MN229 nand_225 B1_10 nd_228 0 NMOS l=6.000000000000001e-08 w=2.0000000000000002e-07
MN230 nd_228 inv_213 0 0 NMOS l=6.000000000000001e-08 w=2.0000000000000002e-07
MP232 inv_231 nand_225 VDD VDD PMOS l=6.000000000000001e-08 w=4.0000000000000003e-07
MN233 inv_231 nand_225 0 0 NMOS l=6.000000000000001e-08 w=2.0000000000000002e-07
MP235 nand_234 B2_11 VDD VDD PMOS l=6.000000000000001e-08 w=4.0000000000000003e-07
MP236 nand_234 inv_213 VDD VDD PMOS l=6.000000000000001e-08 w=4.0000000000000003e-07
MN238 nand_234 B2_11 nd_237 0 NMOS l=6.000000000000001e-08 w=2.0000000000000002e-07
MN239 nd_237 inv_213 0 0 NMOS l=6.000000000000001e-08 w=2.0000000000000002e-07
MP241 inv_240 nand_234 VDD VDD PMOS l=6.000000000000001e-08 w=4.0000000000000003e-07
MN242 inv_240 nand_234 0 0 NMOS l=6.000000000000001e-08 w=2.0000000000000002e-07
MP245 nor_243 inv_105 nu_244 VDD PMOS l=6.000000000000001e-08 w=4.0000000000000003e-07
MP246 nu_244 inv_210 VDD VDD PMOS l=6.000000000000001e-08 w=4.0000000000000003e-07
MN247 nor_243 inv_105 0 0 NMOS l=6.000000000000001e-08 w=2.0000000000000002e-07
MN248 nor_243 inv_210 0 0 NMOS l=6.000000000000001e-08 w=2.0000000000000002e-07
MP250 inv_249 nor_243 VDD VDD PMOS l=6.000000000000001e-08 w=4.0000000000000003e-07
MN251 inv_249 nor_243 0 0 NMOS l=6.000000000000001e-08 w=2.0000000000000002e-07
MP254 inv_253 A7_8 VDD VDD PMOS l=6.000000000000001e-08 w=4.0000000000000003e-07
MN255 inv_253 A7_8 0 0 NMOS l=6.000000000000001e-08 w=2.0000000000000002e-07
MP257 inv_256 B7_16 VDD VDD PMOS l=6.000000000000001e-08 w=4.0000000000000003e-07
MN258 inv_256 B7_16 0 0 NMOS l=6.000000000000001e-08 w=2.0000000000000002e-07
MN259 A7_8 inv_256 xor_252 0 NMOS l=6.000000000000001e-08 w=2.0000000000000002e-07
MP260 A7_8 B7_16 xor_252 VDD PMOS l=6.000000000000001e-08 w=4.0000000000000003e-07
MN261 inv_253 B7_16 xor_252 0 NMOS l=6.000000000000001e-08 w=2.0000000000000002e-07
MP262 inv_253 inv_256 xor_252 VDD PMOS l=6.000000000000001e-08 w=4.0000000000000003e-07
MP264 nand_263 inv_117 VDD VDD PMOS l=6.000000000000001e-08 w=4.0000000000000003e-07
MP265 nand_263 inv_222 VDD VDD PMOS l=6.000000000000001e-08 w=4.0000000000000003e-07
MN267 nand_263 inv_117 nd_266 0 NMOS l=6.000000000000001e-08 w=2.0000000000000002e-07
MN268 nd_266 inv_222 0 0 NMOS l=6.000000000000001e-08 w=2.0000000000000002e-07
MP270 inv_269 nand_263 VDD VDD PMOS l=6.000000000000001e-08 w=4.0000000000000003e-07
MN271 inv_269 nand_263 0 0 NMOS l=6.000000000000001e-08 w=2.0000000000000002e-07
MP273 nand_272 inv_117 VDD VDD PMOS l=6.000000000000001e-08 w=4.0000000000000003e-07
MP274 nand_272 inv_231 VDD VDD PMOS l=6.000000000000001e-08 w=4.0000000000000003e-07
MN276 nand_272 inv_117 nd_275 0 NMOS l=6.000000000000001e-08 w=2.0000000000000002e-07
MN277 nd_275 inv_231 0 0 NMOS l=6.000000000000001e-08 w=2.0000000000000002e-07
MP279 inv_278 nand_272 VDD VDD PMOS l=6.000000000000001e-08 w=4.0000000000000003e-07
MN280 inv_278 nand_272 0 0 NMOS l=6.000000000000001e-08 w=2.0000000000000002e-07
MP282 nand_281 inv_117 VDD VDD PMOS l=6.000000000000001e-08 w=4.0000000000000003e-07
MP283 nand_281 inv_240 VDD VDD PMOS l=6.000000000000001e-08 w=4.0000000000000003e-07
MN285 nand_281 inv_117 nd_284 0 NMOS l=6.000000000000001e-08 w=2.0000000000000002e-07
MN286 nd_284 inv_240 0 0 NMOS l=6.000000000000001e-08 w=2.0000000000000002e-07
MP288 inv_287 nand_281 VDD VDD PMOS l=6.000000000000001e-08 w=4.0000000000000003e-07
MN289 inv_287 nand_281 0 0 NMOS l=6.000000000000001e-08 w=2.0000000000000002e-07
MP291 nand_290 inv_117 VDD VDD PMOS l=6.000000000000001e-08 w=4.0000000000000003e-07
MP292 nand_290 inv_213 VDD VDD PMOS l=6.000000000000001e-08 w=4.0000000000000003e-07
MN294 nand_290 inv_117 nd_293 0 NMOS l=6.000000000000001e-08 w=2.0000000000000002e-07
MN295 nd_293 inv_213 0 0 NMOS l=6.000000000000001e-08 w=2.0000000000000002e-07
MP297 inv_296 nand_290 VDD VDD PMOS l=6.000000000000001e-08 w=4.0000000000000003e-07
MN298 inv_296 nand_290 0 0 NMOS l=6.000000000000001e-08 w=2.0000000000000002e-07
MP300 nand_299 inv_126 VDD VDD PMOS l=6.000000000000001e-08 w=4.0000000000000003e-07
MP301 nand_299 inv_222 VDD VDD PMOS l=6.000000000000001e-08 w=4.0000000000000003e-07
MN303 nand_299 inv_126 nd_302 0 NMOS l=6.000000000000001e-08 w=2.0000000000000002e-07
MN304 nd_302 inv_222 0 0 NMOS l=6.000000000000001e-08 w=2.0000000000000002e-07
MP306 inv_305 nand_299 VDD VDD PMOS l=6.000000000000001e-08 w=4.0000000000000003e-07
MN307 inv_305 nand_299 0 0 NMOS l=6.000000000000001e-08 w=2.0000000000000002e-07
MP309 nand_308 inv_126 VDD VDD PMOS l=6.000000000000001e-08 w=4.0000000000000003e-07
MP310 nand_308 inv_231 VDD VDD PMOS l=6.000000000000001e-08 w=4.0000000000000003e-07
MN312 nand_308 inv_126 nd_311 0 NMOS l=6.000000000000001e-08 w=2.0000000000000002e-07
MN313 nd_311 inv_231 0 0 NMOS l=6.000000000000001e-08 w=2.0000000000000002e-07
MP315 inv_314 nand_308 VDD VDD PMOS l=6.000000000000001e-08 w=4.0000000000000003e-07
MN316 inv_314 nand_308 0 0 NMOS l=6.000000000000001e-08 w=2.0000000000000002e-07
MP318 nand_317 inv_126 VDD VDD PMOS l=6.000000000000001e-08 w=4.0000000000000003e-07
MP319 nand_317 inv_240 VDD VDD PMOS l=6.000000000000001e-08 w=4.0000000000000003e-07
MN321 nand_317 inv_126 nd_320 0 NMOS l=6.000000000000001e-08 w=2.0000000000000002e-07
MN322 nd_320 inv_240 0 0 NMOS l=6.000000000000001e-08 w=2.0000000000000002e-07
MP324 inv_323 nand_317 VDD VDD PMOS l=6.000000000000001e-08 w=4.0000000000000003e-07
MN325 inv_323 nand_317 0 0 NMOS l=6.000000000000001e-08 w=2.0000000000000002e-07
MP327 nand_326 inv_126 VDD VDD PMOS l=6.000000000000001e-08 w=4.0000000000000003e-07
MP328 nand_326 inv_213 VDD VDD PMOS l=6.000000000000001e-08 w=4.0000000000000003e-07
MN330 nand_326 inv_126 nd_329 0 NMOS l=6.000000000000001e-08 w=2.0000000000000002e-07
MN331 nd_329 inv_213 0 0 NMOS l=6.000000000000001e-08 w=2.0000000000000002e-07
MP333 inv_332 nand_326 VDD VDD PMOS l=6.000000000000001e-08 w=4.0000000000000003e-07
MN334 inv_332 nand_326 0 0 NMOS l=6.000000000000001e-08 w=2.0000000000000002e-07
MP336 nand_335 inv_135 VDD VDD PMOS l=6.000000000000001e-08 w=4.0000000000000003e-07
MP337 nand_335 inv_222 VDD VDD PMOS l=6.000000000000001e-08 w=4.0000000000000003e-07
MN339 nand_335 inv_135 nd_338 0 NMOS l=6.000000000000001e-08 w=2.0000000000000002e-07
MN340 nd_338 inv_222 0 0 NMOS l=6.000000000000001e-08 w=2.0000000000000002e-07
MP342 inv_341 nand_335 VDD VDD PMOS l=6.000000000000001e-08 w=4.0000000000000003e-07
MN343 inv_341 nand_335 0 0 NMOS l=6.000000000000001e-08 w=2.0000000000000002e-07
MP345 nand_344 inv_135 VDD VDD PMOS l=6.000000000000001e-08 w=4.0000000000000003e-07
MP346 nand_344 inv_231 VDD VDD PMOS l=6.000000000000001e-08 w=4.0000000000000003e-07
MN348 nand_344 inv_135 nd_347 0 NMOS l=6.000000000000001e-08 w=2.0000000000000002e-07
MN349 nd_347 inv_231 0 0 NMOS l=6.000000000000001e-08 w=2.0000000000000002e-07
MP351 inv_350 nand_344 VDD VDD PMOS l=6.000000000000001e-08 w=4.0000000000000003e-07
MN352 inv_350 nand_344 0 0 NMOS l=6.000000000000001e-08 w=2.0000000000000002e-07
MP354 nand_353 inv_135 VDD VDD PMOS l=6.000000000000001e-08 w=4.0000000000000003e-07
MP355 nand_353 inv_240 VDD VDD PMOS l=6.000000000000001e-08 w=4.0000000000000003e-07
MN357 nand_353 inv_135 nd_356 0 NMOS l=6.000000000000001e-08 w=2.0000000000000002e-07
MN358 nd_356 inv_240 0 0 NMOS l=6.000000000000001e-08 w=2.0000000000000002e-07
MP360 inv_359 nand_353 VDD VDD PMOS l=6.000000000000001e-08 w=4.0000000000000003e-07
MN361 inv_359 nand_353 0 0 NMOS l=6.000000000000001e-08 w=2.0000000000000002e-07
MP363 nand_362 inv_135 VDD VDD PMOS l=6.000000000000001e-08 w=4.0000000000000003e-07
MP364 nand_362 inv_213 VDD VDD PMOS l=6.000000000000001e-08 w=4.0000000000000003e-07
MN366 nand_362 inv_135 nd_365 0 NMOS l=6.000000000000001e-08 w=2.0000000000000002e-07
MN367 nd_365 inv_213 0 0 NMOS l=6.000000000000001e-08 w=2.0000000000000002e-07
MP369 inv_368 nand_362 VDD VDD PMOS l=6.000000000000001e-08 w=4.0000000000000003e-07
MN370 inv_368 nand_362 0 0 NMOS l=6.000000000000001e-08 w=2.0000000000000002e-07
MP372 nand_371 inv_108 VDD VDD PMOS l=6.000000000000001e-08 w=4.0000000000000003e-07
MP373 nand_371 inv_222 VDD VDD PMOS l=6.000000000000001e-08 w=4.0000000000000003e-07
MN375 nand_371 inv_108 nd_374 0 NMOS l=6.000000000000001e-08 w=2.0000000000000002e-07
MN376 nd_374 inv_222 0 0 NMOS l=6.000000000000001e-08 w=2.0000000000000002e-07
MP378 inv_377 nand_371 VDD VDD PMOS l=6.000000000000001e-08 w=4.0000000000000003e-07
MN379 inv_377 nand_371 0 0 NMOS l=6.000000000000001e-08 w=2.0000000000000002e-07
MP381 nand_380 inv_108 VDD VDD PMOS l=6.000000000000001e-08 w=4.0000000000000003e-07
MP382 nand_380 inv_231 VDD VDD PMOS l=6.000000000000001e-08 w=4.0000000000000003e-07
MN384 nand_380 inv_108 nd_383 0 NMOS l=6.000000000000001e-08 w=2.0000000000000002e-07
MN385 nd_383 inv_231 0 0 NMOS l=6.000000000000001e-08 w=2.0000000000000002e-07
MP387 inv_386 nand_380 VDD VDD PMOS l=6.000000000000001e-08 w=4.0000000000000003e-07
MN388 inv_386 nand_380 0 0 NMOS l=6.000000000000001e-08 w=2.0000000000000002e-07
MP390 nand_389 inv_108 VDD VDD PMOS l=6.000000000000001e-08 w=4.0000000000000003e-07
MP391 nand_389 inv_240 VDD VDD PMOS l=6.000000000000001e-08 w=4.0000000000000003e-07
MN393 nand_389 inv_108 nd_392 0 NMOS l=6.000000000000001e-08 w=2.0000000000000002e-07
MN394 nd_392 inv_240 0 0 NMOS l=6.000000000000001e-08 w=2.0000000000000002e-07
MP396 inv_395 nand_389 VDD VDD PMOS l=6.000000000000001e-08 w=4.0000000000000003e-07
MN397 inv_395 nand_389 0 0 NMOS l=6.000000000000001e-08 w=2.0000000000000002e-07
MP399 nand_398 inv_108 VDD VDD PMOS l=6.000000000000001e-08 w=4.0000000000000003e-07
MP400 nand_398 inv_213 VDD VDD PMOS l=6.000000000000001e-08 w=4.0000000000000003e-07
MN402 nand_398 inv_108 nd_401 0 NMOS l=6.000000000000001e-08 w=2.0000000000000002e-07
MN403 nd_401 inv_213 0 0 NMOS l=6.000000000000001e-08 w=2.0000000000000002e-07
MP405 inv_404 nand_398 VDD VDD PMOS l=6.000000000000001e-08 w=4.0000000000000003e-07
MN406 inv_404 nand_398 0 0 NMOS l=6.000000000000001e-08 w=2.0000000000000002e-07
MP408 inv_407 inv_278 VDD VDD PMOS l=6.000000000000001e-08 w=4.0000000000000003e-07
MN409 inv_407 inv_278 0 0 NMOS l=6.000000000000001e-08 w=2.0000000000000002e-07
MP411 inv_410 inv_305 VDD VDD PMOS l=6.000000000000001e-08 w=4.0000000000000003e-07
MN412 inv_410 inv_305 0 0 NMOS l=6.000000000000001e-08 w=2.0000000000000002e-07
MN414 inv_278 inv_410 xor_413 0 NMOS l=6.000000000000001e-08 w=2.0000000000000002e-07
MP415 inv_278 inv_305 xor_413 VDD PMOS l=6.000000000000001e-08 w=4.0000000000000003e-07
MN416 inv_407 inv_305 xor_413 0 NMOS l=6.000000000000001e-08 w=2.0000000000000002e-07
MP417 inv_407 inv_410 xor_413 VDD PMOS l=6.000000000000001e-08 w=4.0000000000000003e-07
MP419 nand_418 inv_278 VDD VDD PMOS l=6.000000000000001e-08 w=4.0000000000000003e-07
MP420 nand_418 inv_305 VDD VDD PMOS l=6.000000000000001e-08 w=4.0000000000000003e-07
MN422 nand_418 inv_278 nd_421 0 NMOS l=6.000000000000001e-08 w=2.0000000000000002e-07
MN423 nd_421 inv_305 0 0 NMOS l=6.000000000000001e-08 w=2.0000000000000002e-07
MP425 inv_424 nand_418 VDD VDD PMOS l=6.000000000000001e-08 w=4.0000000000000003e-07
MN426 inv_424 nand_418 0 0 NMOS l=6.000000000000001e-08 w=2.0000000000000002e-07
MP428 inv_427 inv_287 VDD VDD PMOS l=6.000000000000001e-08 w=4.0000000000000003e-07
MN429 inv_427 inv_287 0 0 NMOS l=6.000000000000001e-08 w=2.0000000000000002e-07
MP431 inv_430 inv_314 VDD VDD PMOS l=6.000000000000001e-08 w=4.0000000000000003e-07
MN432 inv_430 inv_314 0 0 NMOS l=6.000000000000001e-08 w=2.0000000000000002e-07
MN434 inv_287 inv_430 xor_433 0 NMOS l=6.000000000000001e-08 w=2.0000000000000002e-07
MP435 inv_287 inv_314 xor_433 VDD PMOS l=6.000000000000001e-08 w=4.0000000000000003e-07
MN436 inv_427 inv_314 xor_433 0 NMOS l=6.000000000000001e-08 w=2.0000000000000002e-07
MP437 inv_427 inv_430 xor_433 VDD PMOS l=6.000000000000001e-08 w=4.0000000000000003e-07
MP439 inv_438 xor_433 VDD VDD PMOS l=6.000000000000001e-08 w=4.0000000000000003e-07
MN440 inv_438 xor_433 0 0 NMOS l=6.000000000000001e-08 w=2.0000000000000002e-07
MP442 inv_441 inv_341 VDD VDD PMOS l=6.000000000000001e-08 w=4.0000000000000003e-07
MN443 inv_441 inv_341 0 0 NMOS l=6.000000000000001e-08 w=2.0000000000000002e-07
MN445 xor_433 inv_441 xor_444 0 NMOS l=6.000000000000001e-08 w=2.0000000000000002e-07
MP446 xor_433 inv_341 xor_444 VDD PMOS l=6.000000000000001e-08 w=4.0000000000000003e-07
MN447 inv_438 inv_341 xor_444 0 NMOS l=6.000000000000001e-08 w=2.0000000000000002e-07
MP448 inv_438 inv_441 xor_444 VDD PMOS l=6.000000000000001e-08 w=4.0000000000000003e-07
MN450 inv_341 xor_433 cout_449 0 NMOS l=6.000000000000001e-08 w=2.0000000000000002e-07
MP451 inv_341 inv_438 cout_449 VDD PMOS l=6.000000000000001e-08 w=4.0000000000000003e-07
MN452 inv_287 inv_438 cout_449 0 NMOS l=6.000000000000001e-08 w=2.0000000000000002e-07
MP453 inv_287 xor_433 cout_449 VDD PMOS l=6.000000000000001e-08 w=4.0000000000000003e-07
MP455 inv_454 cout_449 VDD VDD PMOS l=6.000000000000001e-08 w=4.0000000000000003e-07
MN456 inv_454 cout_449 0 0 NMOS l=6.000000000000001e-08 w=2.0000000000000002e-07
MP458 inv_457 inv_454 VDD VDD PMOS l=6.000000000000001e-08 w=4.0000000000000003e-07
MN459 inv_457 inv_454 0 0 NMOS l=6.000000000000001e-08 w=2.0000000000000002e-07
MP461 inv_460 inv_296 VDD VDD PMOS l=6.000000000000001e-08 w=4.0000000000000003e-07
MN462 inv_460 inv_296 0 0 NMOS l=6.000000000000001e-08 w=2.0000000000000002e-07
MP464 inv_463 inv_323 VDD VDD PMOS l=6.000000000000001e-08 w=4.0000000000000003e-07
MN465 inv_463 inv_323 0 0 NMOS l=6.000000000000001e-08 w=2.0000000000000002e-07
MN467 inv_296 inv_463 xor_466 0 NMOS l=6.000000000000001e-08 w=2.0000000000000002e-07
MP468 inv_296 inv_323 xor_466 VDD PMOS l=6.000000000000001e-08 w=4.0000000000000003e-07
MN469 inv_460 inv_323 xor_466 0 NMOS l=6.000000000000001e-08 w=2.0000000000000002e-07
MP470 inv_460 inv_463 xor_466 VDD PMOS l=6.000000000000001e-08 w=4.0000000000000003e-07
MP472 inv_471 xor_466 VDD VDD PMOS l=6.000000000000001e-08 w=4.0000000000000003e-07
MN473 inv_471 xor_466 0 0 NMOS l=6.000000000000001e-08 w=2.0000000000000002e-07
MP475 inv_474 inv_350 VDD VDD PMOS l=6.000000000000001e-08 w=4.0000000000000003e-07
MN476 inv_474 inv_350 0 0 NMOS l=6.000000000000001e-08 w=2.0000000000000002e-07
MN478 xor_466 inv_474 xor_477 0 NMOS l=6.000000000000001e-08 w=2.0000000000000002e-07
MP479 xor_466 inv_350 xor_477 VDD PMOS l=6.000000000000001e-08 w=4.0000000000000003e-07
MN480 inv_471 inv_350 xor_477 0 NMOS l=6.000000000000001e-08 w=2.0000000000000002e-07
MP481 inv_471 inv_474 xor_477 VDD PMOS l=6.000000000000001e-08 w=4.0000000000000003e-07
MN483 inv_350 xor_466 cout_482 0 NMOS l=6.000000000000001e-08 w=2.0000000000000002e-07
MP484 inv_350 inv_471 cout_482 VDD PMOS l=6.000000000000001e-08 w=4.0000000000000003e-07
MN485 inv_296 inv_471 cout_482 0 NMOS l=6.000000000000001e-08 w=2.0000000000000002e-07
MP486 inv_296 xor_466 cout_482 VDD PMOS l=6.000000000000001e-08 w=4.0000000000000003e-07
MP488 inv_487 cout_482 VDD VDD PMOS l=6.000000000000001e-08 w=4.0000000000000003e-07
MN489 inv_487 cout_482 0 0 NMOS l=6.000000000000001e-08 w=2.0000000000000002e-07
MP491 inv_490 inv_487 VDD VDD PMOS l=6.000000000000001e-08 w=4.0000000000000003e-07
MN492 inv_490 inv_487 0 0 NMOS l=6.000000000000001e-08 w=2.0000000000000002e-07
MP494 inv_493 inv_332 VDD VDD PMOS l=6.000000000000001e-08 w=4.0000000000000003e-07
MN495 inv_493 inv_332 0 0 NMOS l=6.000000000000001e-08 w=2.0000000000000002e-07
MP497 inv_496 inv_359 VDD VDD PMOS l=6.000000000000001e-08 w=4.0000000000000003e-07
MN498 inv_496 inv_359 0 0 NMOS l=6.000000000000001e-08 w=2.0000000000000002e-07
MN500 inv_332 inv_496 xor_499 0 NMOS l=6.000000000000001e-08 w=2.0000000000000002e-07
MP501 inv_332 inv_359 xor_499 VDD PMOS l=6.000000000000001e-08 w=4.0000000000000003e-07
MN502 inv_493 inv_359 xor_499 0 NMOS l=6.000000000000001e-08 w=2.0000000000000002e-07
MP503 inv_493 inv_496 xor_499 VDD PMOS l=6.000000000000001e-08 w=4.0000000000000003e-07
MP505 inv_504 xor_499 VDD VDD PMOS l=6.000000000000001e-08 w=4.0000000000000003e-07
MN506 inv_504 xor_499 0 0 NMOS l=6.000000000000001e-08 w=2.0000000000000002e-07
MP508 inv_507 inv_386 VDD VDD PMOS l=6.000000000000001e-08 w=4.0000000000000003e-07
MN509 inv_507 inv_386 0 0 NMOS l=6.000000000000001e-08 w=2.0000000000000002e-07
MN511 xor_499 inv_507 xor_510 0 NMOS l=6.000000000000001e-08 w=2.0000000000000002e-07
MP512 xor_499 inv_386 xor_510 VDD PMOS l=6.000000000000001e-08 w=4.0000000000000003e-07
MN513 inv_504 inv_386 xor_510 0 NMOS l=6.000000000000001e-08 w=2.0000000000000002e-07
MP514 inv_504 inv_507 xor_510 VDD PMOS l=6.000000000000001e-08 w=4.0000000000000003e-07
MN516 inv_386 xor_499 cout_515 0 NMOS l=6.000000000000001e-08 w=2.0000000000000002e-07
MP517 inv_386 inv_504 cout_515 VDD PMOS l=6.000000000000001e-08 w=4.0000000000000003e-07
MN518 inv_332 inv_504 cout_515 0 NMOS l=6.000000000000001e-08 w=2.0000000000000002e-07
MP519 inv_332 xor_499 cout_515 VDD PMOS l=6.000000000000001e-08 w=4.0000000000000003e-07
MP521 inv_520 cout_515 VDD VDD PMOS l=6.000000000000001e-08 w=4.0000000000000003e-07
MN522 inv_520 cout_515 0 0 NMOS l=6.000000000000001e-08 w=2.0000000000000002e-07
MP524 inv_523 inv_520 VDD VDD PMOS l=6.000000000000001e-08 w=4.0000000000000003e-07
MN525 inv_523 inv_520 0 0 NMOS l=6.000000000000001e-08 w=2.0000000000000002e-07
MP527 inv_526 inv_368 VDD VDD PMOS l=6.000000000000001e-08 w=4.0000000000000003e-07
MN528 inv_526 inv_368 0 0 NMOS l=6.000000000000001e-08 w=2.0000000000000002e-07
MP530 inv_529 inv_395 VDD VDD PMOS l=6.000000000000001e-08 w=4.0000000000000003e-07
MN531 inv_529 inv_395 0 0 NMOS l=6.000000000000001e-08 w=2.0000000000000002e-07
MN533 inv_368 inv_529 xor_532 0 NMOS l=6.000000000000001e-08 w=2.0000000000000002e-07
MP534 inv_368 inv_395 xor_532 VDD PMOS l=6.000000000000001e-08 w=4.0000000000000003e-07
MN535 inv_526 inv_395 xor_532 0 NMOS l=6.000000000000001e-08 w=2.0000000000000002e-07
MP536 inv_526 inv_529 xor_532 VDD PMOS l=6.000000000000001e-08 w=4.0000000000000003e-07
MP538 nand_537 inv_368 VDD VDD PMOS l=6.000000000000001e-08 w=4.0000000000000003e-07
MP539 nand_537 inv_395 VDD VDD PMOS l=6.000000000000001e-08 w=4.0000000000000003e-07
MN541 nand_537 inv_368 nd_540 0 NMOS l=6.000000000000001e-08 w=2.0000000000000002e-07
MN542 nd_540 inv_395 0 0 NMOS l=6.000000000000001e-08 w=2.0000000000000002e-07
MP544 inv_543 nand_537 VDD VDD PMOS l=6.000000000000001e-08 w=4.0000000000000003e-07
MN545 inv_543 nand_537 0 0 NMOS l=6.000000000000001e-08 w=2.0000000000000002e-07
MP547 inv_546 inv_424 VDD VDD PMOS l=6.000000000000001e-08 w=4.0000000000000003e-07
MN548 inv_546 inv_424 0 0 NMOS l=6.000000000000001e-08 w=2.0000000000000002e-07
MP550 inv_549 xor_444 VDD VDD PMOS l=6.000000000000001e-08 w=4.0000000000000003e-07
MN551 inv_549 xor_444 0 0 NMOS l=6.000000000000001e-08 w=2.0000000000000002e-07
MN553 inv_424 inv_549 xor_552 0 NMOS l=6.000000000000001e-08 w=2.0000000000000002e-07
MP554 inv_424 xor_444 xor_552 VDD PMOS l=6.000000000000001e-08 w=4.0000000000000003e-07
MN555 inv_546 xor_444 xor_552 0 NMOS l=6.000000000000001e-08 w=2.0000000000000002e-07
MP556 inv_546 inv_549 xor_552 VDD PMOS l=6.000000000000001e-08 w=4.0000000000000003e-07
MP558 nand_557 inv_424 VDD VDD PMOS l=6.000000000000001e-08 w=4.0000000000000003e-07
MP559 nand_557 xor_444 VDD VDD PMOS l=6.000000000000001e-08 w=4.0000000000000003e-07
MN561 nand_557 inv_424 nd_560 0 NMOS l=6.000000000000001e-08 w=2.0000000000000002e-07
MN562 nd_560 xor_444 0 0 NMOS l=6.000000000000001e-08 w=2.0000000000000002e-07
MP564 inv_563 nand_557 VDD VDD PMOS l=6.000000000000001e-08 w=4.0000000000000003e-07
MN565 inv_563 nand_557 0 0 NMOS l=6.000000000000001e-08 w=2.0000000000000002e-07
MP567 inv_566 inv_457 VDD VDD PMOS l=6.000000000000001e-08 w=4.0000000000000003e-07
MN568 inv_566 inv_457 0 0 NMOS l=6.000000000000001e-08 w=2.0000000000000002e-07
MP570 inv_569 xor_477 VDD VDD PMOS l=6.000000000000001e-08 w=4.0000000000000003e-07
MN571 inv_569 xor_477 0 0 NMOS l=6.000000000000001e-08 w=2.0000000000000002e-07
MN573 inv_457 inv_569 xor_572 0 NMOS l=6.000000000000001e-08 w=2.0000000000000002e-07
MP574 inv_457 xor_477 xor_572 VDD PMOS l=6.000000000000001e-08 w=4.0000000000000003e-07
MN575 inv_566 xor_477 xor_572 0 NMOS l=6.000000000000001e-08 w=2.0000000000000002e-07
MP576 inv_566 inv_569 xor_572 VDD PMOS l=6.000000000000001e-08 w=4.0000000000000003e-07
MP578 inv_577 xor_572 VDD VDD PMOS l=6.000000000000001e-08 w=4.0000000000000003e-07
MN579 inv_577 xor_572 0 0 NMOS l=6.000000000000001e-08 w=2.0000000000000002e-07
MP581 inv_580 inv_377 VDD VDD PMOS l=6.000000000000001e-08 w=4.0000000000000003e-07
MN582 inv_580 inv_377 0 0 NMOS l=6.000000000000001e-08 w=2.0000000000000002e-07
MN584 xor_572 inv_580 xor_583 0 NMOS l=6.000000000000001e-08 w=2.0000000000000002e-07
MP585 xor_572 inv_377 xor_583 VDD PMOS l=6.000000000000001e-08 w=4.0000000000000003e-07
MN586 inv_577 inv_377 xor_583 0 NMOS l=6.000000000000001e-08 w=2.0000000000000002e-07
MP587 inv_577 inv_580 xor_583 VDD PMOS l=6.000000000000001e-08 w=4.0000000000000003e-07
MN589 inv_377 xor_572 cout_588 0 NMOS l=6.000000000000001e-08 w=2.0000000000000002e-07
MP590 inv_377 inv_577 cout_588 VDD PMOS l=6.000000000000001e-08 w=4.0000000000000003e-07
MN591 inv_457 inv_577 cout_588 0 NMOS l=6.000000000000001e-08 w=2.0000000000000002e-07
MP592 inv_457 xor_572 cout_588 VDD PMOS l=6.000000000000001e-08 w=4.0000000000000003e-07
MP594 inv_593 cout_588 VDD VDD PMOS l=6.000000000000001e-08 w=4.0000000000000003e-07
MN595 inv_593 cout_588 0 0 NMOS l=6.000000000000001e-08 w=2.0000000000000002e-07
MP597 inv_596 inv_593 VDD VDD PMOS l=6.000000000000001e-08 w=4.0000000000000003e-07
MN598 inv_596 inv_593 0 0 NMOS l=6.000000000000001e-08 w=2.0000000000000002e-07
MP600 inv_599 inv_490 VDD VDD PMOS l=6.000000000000001e-08 w=4.0000000000000003e-07
MN601 inv_599 inv_490 0 0 NMOS l=6.000000000000001e-08 w=2.0000000000000002e-07
MP603 inv_602 xor_510 VDD VDD PMOS l=6.000000000000001e-08 w=4.0000000000000003e-07
MN604 inv_602 xor_510 0 0 NMOS l=6.000000000000001e-08 w=2.0000000000000002e-07
MN606 inv_490 inv_602 xor_605 0 NMOS l=6.000000000000001e-08 w=2.0000000000000002e-07
MP607 inv_490 xor_510 xor_605 VDD PMOS l=6.000000000000001e-08 w=4.0000000000000003e-07
MN608 inv_599 xor_510 xor_605 0 NMOS l=6.000000000000001e-08 w=2.0000000000000002e-07
MP609 inv_599 inv_602 xor_605 VDD PMOS l=6.000000000000001e-08 w=4.0000000000000003e-07
MP611 nand_610 inv_490 VDD VDD PMOS l=6.000000000000001e-08 w=4.0000000000000003e-07
MP612 nand_610 xor_510 VDD VDD PMOS l=6.000000000000001e-08 w=4.0000000000000003e-07
MN614 nand_610 inv_490 nd_613 0 NMOS l=6.000000000000001e-08 w=2.0000000000000002e-07
MN615 nd_613 xor_510 0 0 NMOS l=6.000000000000001e-08 w=2.0000000000000002e-07
MP617 inv_616 nand_610 VDD VDD PMOS l=6.000000000000001e-08 w=4.0000000000000003e-07
MN618 inv_616 nand_610 0 0 NMOS l=6.000000000000001e-08 w=2.0000000000000002e-07
MP620 inv_619 inv_523 VDD VDD PMOS l=6.000000000000001e-08 w=4.0000000000000003e-07
MN621 inv_619 inv_523 0 0 NMOS l=6.000000000000001e-08 w=2.0000000000000002e-07
MP623 inv_622 xor_532 VDD VDD PMOS l=6.000000000000001e-08 w=4.0000000000000003e-07
MN624 inv_622 xor_532 0 0 NMOS l=6.000000000000001e-08 w=2.0000000000000002e-07
MN626 inv_523 inv_622 xor_625 0 NMOS l=6.000000000000001e-08 w=2.0000000000000002e-07
MP627 inv_523 xor_532 xor_625 VDD PMOS l=6.000000000000001e-08 w=4.0000000000000003e-07
MN628 inv_619 xor_532 xor_625 0 NMOS l=6.000000000000001e-08 w=2.0000000000000002e-07
MP629 inv_619 inv_622 xor_625 VDD PMOS l=6.000000000000001e-08 w=4.0000000000000003e-07
MP631 nand_630 inv_523 VDD VDD PMOS l=6.000000000000001e-08 w=4.0000000000000003e-07
MP632 nand_630 xor_532 VDD VDD PMOS l=6.000000000000001e-08 w=4.0000000000000003e-07
MN634 nand_630 inv_523 nd_633 0 NMOS l=6.000000000000001e-08 w=2.0000000000000002e-07
MN635 nd_633 xor_532 0 0 NMOS l=6.000000000000001e-08 w=2.0000000000000002e-07
MP637 inv_636 nand_630 VDD VDD PMOS l=6.000000000000001e-08 w=4.0000000000000003e-07
MN638 inv_636 nand_630 0 0 NMOS l=6.000000000000001e-08 w=2.0000000000000002e-07
MP640 inv_639 inv_543 VDD VDD PMOS l=6.000000000000001e-08 w=4.0000000000000003e-07
MN641 inv_639 inv_543 0 0 NMOS l=6.000000000000001e-08 w=2.0000000000000002e-07
MP643 inv_642 inv_404 VDD VDD PMOS l=6.000000000000001e-08 w=4.0000000000000003e-07
MN644 inv_642 inv_404 0 0 NMOS l=6.000000000000001e-08 w=2.0000000000000002e-07
MN646 inv_543 inv_642 xor_645 0 NMOS l=6.000000000000001e-08 w=2.0000000000000002e-07
MP647 inv_543 inv_404 xor_645 VDD PMOS l=6.000000000000001e-08 w=4.0000000000000003e-07
MN648 inv_639 inv_404 xor_645 0 NMOS l=6.000000000000001e-08 w=2.0000000000000002e-07
MP649 inv_639 inv_642 xor_645 VDD PMOS l=6.000000000000001e-08 w=4.0000000000000003e-07
MP651 nand_650 inv_543 VDD VDD PMOS l=6.000000000000001e-08 w=4.0000000000000003e-07
MP652 nand_650 inv_404 VDD VDD PMOS l=6.000000000000001e-08 w=4.0000000000000003e-07
MN654 nand_650 inv_543 nd_653 0 NMOS l=6.000000000000001e-08 w=2.0000000000000002e-07
MN655 nd_653 inv_404 0 0 NMOS l=6.000000000000001e-08 w=2.0000000000000002e-07
MP657 inv_656 nand_650 VDD VDD PMOS l=6.000000000000001e-08 w=4.0000000000000003e-07
MN658 inv_656 nand_650 0 0 NMOS l=6.000000000000001e-08 w=2.0000000000000002e-07
MP660 inv_659 inv_269 VDD VDD PMOS l=6.000000000000001e-08 w=4.0000000000000003e-07
MN661 inv_659 inv_269 0 0 NMOS l=6.000000000000001e-08 w=2.0000000000000002e-07
MP663 inv_662 GND VDD VDD PMOS l=6.000000000000001e-08 w=4.0000000000000003e-07
MN664 inv_662 GND 0 0 NMOS l=6.000000000000001e-08 w=2.0000000000000002e-07
MN666 inv_269 inv_662 xor_665 0 NMOS l=6.000000000000001e-08 w=2.0000000000000002e-07
MP667 inv_269 GND xor_665 VDD PMOS l=6.000000000000001e-08 w=4.0000000000000003e-07
MN668 inv_659 GND xor_665 0 NMOS l=6.000000000000001e-08 w=2.0000000000000002e-07
MP669 inv_659 inv_662 xor_665 VDD PMOS l=6.000000000000001e-08 w=4.0000000000000003e-07
MP671 inv_670 xor_665 VDD VDD PMOS l=6.000000000000001e-08 w=4.0000000000000003e-07
MN672 inv_670 xor_665 0 0 NMOS l=6.000000000000001e-08 w=2.0000000000000002e-07
MP674 inv_673 GND VDD VDD PMOS l=6.000000000000001e-08 w=4.0000000000000003e-07
MN675 inv_673 GND 0 0 NMOS l=6.000000000000001e-08 w=2.0000000000000002e-07
MN677 xor_665 inv_673 xor_676 0 NMOS l=6.000000000000001e-08 w=2.0000000000000002e-07
MP678 xor_665 GND xor_676 VDD PMOS l=6.000000000000001e-08 w=4.0000000000000003e-07
MN679 inv_670 GND xor_676 0 NMOS l=6.000000000000001e-08 w=2.0000000000000002e-07
MP680 inv_670 inv_673 xor_676 VDD PMOS l=6.000000000000001e-08 w=4.0000000000000003e-07
MN682 0 xor_665 cout_681 0 NMOS l=6.000000000000001e-08 w=2.0000000000000002e-07
MP683 0 inv_670 cout_681 VDD PMOS l=6.000000000000001e-08 w=4.0000000000000003e-07
MN684 inv_269 inv_670 cout_681 0 NMOS l=6.000000000000001e-08 w=2.0000000000000002e-07
MP685 inv_269 xor_665 cout_681 VDD PMOS l=6.000000000000001e-08 w=4.0000000000000003e-07
MP687 inv_686 cout_681 VDD VDD PMOS l=6.000000000000001e-08 w=4.0000000000000003e-07
MN688 inv_686 cout_681 0 0 NMOS l=6.000000000000001e-08 w=2.0000000000000002e-07
MP690 inv_689 inv_686 VDD VDD PMOS l=6.000000000000001e-08 w=4.0000000000000003e-07
MN691 inv_689 inv_686 0 0 NMOS l=6.000000000000001e-08 w=2.0000000000000002e-07
MP693 inv_692 xor_413 VDD VDD PMOS l=6.000000000000001e-08 w=4.0000000000000003e-07
MN694 inv_692 xor_413 0 0 NMOS l=6.000000000000001e-08 w=2.0000000000000002e-07
MP696 inv_695 GND VDD VDD PMOS l=6.000000000000001e-08 w=4.0000000000000003e-07
MN697 inv_695 GND 0 0 NMOS l=6.000000000000001e-08 w=2.0000000000000002e-07
MN699 xor_413 inv_695 xor_698 0 NMOS l=6.000000000000001e-08 w=2.0000000000000002e-07
MP700 xor_413 GND xor_698 VDD PMOS l=6.000000000000001e-08 w=4.0000000000000003e-07
MN701 inv_692 GND xor_698 0 NMOS l=6.000000000000001e-08 w=2.0000000000000002e-07
MP702 inv_692 inv_695 xor_698 VDD PMOS l=6.000000000000001e-08 w=4.0000000000000003e-07
MP704 inv_703 xor_698 VDD VDD PMOS l=6.000000000000001e-08 w=4.0000000000000003e-07
MN705 inv_703 xor_698 0 0 NMOS l=6.000000000000001e-08 w=2.0000000000000002e-07
MP707 inv_706 inv_689 VDD VDD PMOS l=6.000000000000001e-08 w=4.0000000000000003e-07
MN708 inv_706 inv_689 0 0 NMOS l=6.000000000000001e-08 w=2.0000000000000002e-07
MN710 xor_698 inv_706 xor_709 0 NMOS l=6.000000000000001e-08 w=2.0000000000000002e-07
MP711 xor_698 inv_689 xor_709 VDD PMOS l=6.000000000000001e-08 w=4.0000000000000003e-07
MN712 inv_703 inv_689 xor_709 0 NMOS l=6.000000000000001e-08 w=2.0000000000000002e-07
MP713 inv_703 inv_706 xor_709 VDD PMOS l=6.000000000000001e-08 w=4.0000000000000003e-07
MN715 inv_689 xor_698 cout_714 0 NMOS l=6.000000000000001e-08 w=2.0000000000000002e-07
MP716 inv_689 inv_703 cout_714 VDD PMOS l=6.000000000000001e-08 w=4.0000000000000003e-07
MN717 xor_413 inv_703 cout_714 0 NMOS l=6.000000000000001e-08 w=2.0000000000000002e-07
MP718 xor_413 xor_698 cout_714 VDD PMOS l=6.000000000000001e-08 w=4.0000000000000003e-07
MP720 inv_719 cout_714 VDD VDD PMOS l=6.000000000000001e-08 w=4.0000000000000003e-07
MN721 inv_719 cout_714 0 0 NMOS l=6.000000000000001e-08 w=2.0000000000000002e-07
MP723 inv_722 inv_719 VDD VDD PMOS l=6.000000000000001e-08 w=4.0000000000000003e-07
MN724 inv_722 inv_719 0 0 NMOS l=6.000000000000001e-08 w=2.0000000000000002e-07
MP726 inv_725 xor_552 VDD VDD PMOS l=6.000000000000001e-08 w=4.0000000000000003e-07
MN727 inv_725 xor_552 0 0 NMOS l=6.000000000000001e-08 w=2.0000000000000002e-07
MP729 inv_728 GND VDD VDD PMOS l=6.000000000000001e-08 w=4.0000000000000003e-07
MN730 inv_728 GND 0 0 NMOS l=6.000000000000001e-08 w=2.0000000000000002e-07
MN732 xor_552 inv_728 xor_731 0 NMOS l=6.000000000000001e-08 w=2.0000000000000002e-07
MP733 xor_552 GND xor_731 VDD PMOS l=6.000000000000001e-08 w=4.0000000000000003e-07
MN734 inv_725 GND xor_731 0 NMOS l=6.000000000000001e-08 w=2.0000000000000002e-07
MP735 inv_725 inv_728 xor_731 VDD PMOS l=6.000000000000001e-08 w=4.0000000000000003e-07
MP737 inv_736 xor_731 VDD VDD PMOS l=6.000000000000001e-08 w=4.0000000000000003e-07
MN738 inv_736 xor_731 0 0 NMOS l=6.000000000000001e-08 w=2.0000000000000002e-07
MP740 inv_739 inv_722 VDD VDD PMOS l=6.000000000000001e-08 w=4.0000000000000003e-07
MN741 inv_739 inv_722 0 0 NMOS l=6.000000000000001e-08 w=2.0000000000000002e-07
MN743 xor_731 inv_739 xor_742 0 NMOS l=6.000000000000001e-08 w=2.0000000000000002e-07
MP744 xor_731 inv_722 xor_742 VDD PMOS l=6.000000000000001e-08 w=4.0000000000000003e-07
MN745 inv_736 inv_722 xor_742 0 NMOS l=6.000000000000001e-08 w=2.0000000000000002e-07
MP746 inv_736 inv_739 xor_742 VDD PMOS l=6.000000000000001e-08 w=4.0000000000000003e-07
MN748 inv_722 xor_731 cout_747 0 NMOS l=6.000000000000001e-08 w=2.0000000000000002e-07
MP749 inv_722 inv_736 cout_747 VDD PMOS l=6.000000000000001e-08 w=4.0000000000000003e-07
MN750 xor_552 inv_736 cout_747 0 NMOS l=6.000000000000001e-08 w=2.0000000000000002e-07
MP751 xor_552 xor_731 cout_747 VDD PMOS l=6.000000000000001e-08 w=4.0000000000000003e-07
MP753 inv_752 cout_747 VDD VDD PMOS l=6.000000000000001e-08 w=4.0000000000000003e-07
MN754 inv_752 cout_747 0 0 NMOS l=6.000000000000001e-08 w=2.0000000000000002e-07
MP756 inv_755 inv_752 VDD VDD PMOS l=6.000000000000001e-08 w=4.0000000000000003e-07
MN757 inv_755 inv_752 0 0 NMOS l=6.000000000000001e-08 w=2.0000000000000002e-07
MP759 inv_758 inv_563 VDD VDD PMOS l=6.000000000000001e-08 w=4.0000000000000003e-07
MN760 inv_758 inv_563 0 0 NMOS l=6.000000000000001e-08 w=2.0000000000000002e-07
MP762 inv_761 xor_583 VDD VDD PMOS l=6.000000000000001e-08 w=4.0000000000000003e-07
MN763 inv_761 xor_583 0 0 NMOS l=6.000000000000001e-08 w=2.0000000000000002e-07
MN765 inv_563 inv_761 xor_764 0 NMOS l=6.000000000000001e-08 w=2.0000000000000002e-07
MP766 inv_563 xor_583 xor_764 VDD PMOS l=6.000000000000001e-08 w=4.0000000000000003e-07
MN767 inv_758 xor_583 xor_764 0 NMOS l=6.000000000000001e-08 w=2.0000000000000002e-07
MP768 inv_758 inv_761 xor_764 VDD PMOS l=6.000000000000001e-08 w=4.0000000000000003e-07
MP770 inv_769 xor_764 VDD VDD PMOS l=6.000000000000001e-08 w=4.0000000000000003e-07
MN771 inv_769 xor_764 0 0 NMOS l=6.000000000000001e-08 w=2.0000000000000002e-07
MP773 inv_772 inv_755 VDD VDD PMOS l=6.000000000000001e-08 w=4.0000000000000003e-07
MN774 inv_772 inv_755 0 0 NMOS l=6.000000000000001e-08 w=2.0000000000000002e-07
MN776 xor_764 inv_772 xor_775 0 NMOS l=6.000000000000001e-08 w=2.0000000000000002e-07
MP777 xor_764 inv_755 xor_775 VDD PMOS l=6.000000000000001e-08 w=4.0000000000000003e-07
MN778 inv_769 inv_755 xor_775 0 NMOS l=6.000000000000001e-08 w=2.0000000000000002e-07
MP779 inv_769 inv_772 xor_775 VDD PMOS l=6.000000000000001e-08 w=4.0000000000000003e-07
MN781 inv_755 xor_764 cout_780 0 NMOS l=6.000000000000001e-08 w=2.0000000000000002e-07
MP782 inv_755 inv_769 cout_780 VDD PMOS l=6.000000000000001e-08 w=4.0000000000000003e-07
MN783 inv_563 inv_769 cout_780 0 NMOS l=6.000000000000001e-08 w=2.0000000000000002e-07
MP784 inv_563 xor_764 cout_780 VDD PMOS l=6.000000000000001e-08 w=4.0000000000000003e-07
MP786 inv_785 cout_780 VDD VDD PMOS l=6.000000000000001e-08 w=4.0000000000000003e-07
MN787 inv_785 cout_780 0 0 NMOS l=6.000000000000001e-08 w=2.0000000000000002e-07
MP789 inv_788 inv_785 VDD VDD PMOS l=6.000000000000001e-08 w=4.0000000000000003e-07
MN790 inv_788 inv_785 0 0 NMOS l=6.000000000000001e-08 w=2.0000000000000002e-07
MP792 inv_791 inv_596 VDD VDD PMOS l=6.000000000000001e-08 w=4.0000000000000003e-07
MN793 inv_791 inv_596 0 0 NMOS l=6.000000000000001e-08 w=2.0000000000000002e-07
MP795 inv_794 xor_605 VDD VDD PMOS l=6.000000000000001e-08 w=4.0000000000000003e-07
MN796 inv_794 xor_605 0 0 NMOS l=6.000000000000001e-08 w=2.0000000000000002e-07
MN798 inv_596 inv_794 xor_797 0 NMOS l=6.000000000000001e-08 w=2.0000000000000002e-07
MP799 inv_596 xor_605 xor_797 VDD PMOS l=6.000000000000001e-08 w=4.0000000000000003e-07
MN800 inv_791 xor_605 xor_797 0 NMOS l=6.000000000000001e-08 w=2.0000000000000002e-07
MP801 inv_791 inv_794 xor_797 VDD PMOS l=6.000000000000001e-08 w=4.0000000000000003e-07
MP803 inv_802 xor_797 VDD VDD PMOS l=6.000000000000001e-08 w=4.0000000000000003e-07
MN804 inv_802 xor_797 0 0 NMOS l=6.000000000000001e-08 w=2.0000000000000002e-07
MP806 inv_805 inv_788 VDD VDD PMOS l=6.000000000000001e-08 w=4.0000000000000003e-07
MN807 inv_805 inv_788 0 0 NMOS l=6.000000000000001e-08 w=2.0000000000000002e-07
MN809 xor_797 inv_805 xor_808 0 NMOS l=6.000000000000001e-08 w=2.0000000000000002e-07
MP810 xor_797 inv_788 xor_808 VDD PMOS l=6.000000000000001e-08 w=4.0000000000000003e-07
MN811 inv_802 inv_788 xor_808 0 NMOS l=6.000000000000001e-08 w=2.0000000000000002e-07
MP812 inv_802 inv_805 xor_808 VDD PMOS l=6.000000000000001e-08 w=4.0000000000000003e-07
MN814 inv_788 xor_797 cout_813 0 NMOS l=6.000000000000001e-08 w=2.0000000000000002e-07
MP815 inv_788 inv_802 cout_813 VDD PMOS l=6.000000000000001e-08 w=4.0000000000000003e-07
MN816 inv_596 inv_802 cout_813 0 NMOS l=6.000000000000001e-08 w=2.0000000000000002e-07
MP817 inv_596 xor_797 cout_813 VDD PMOS l=6.000000000000001e-08 w=4.0000000000000003e-07
MP819 inv_818 cout_813 VDD VDD PMOS l=6.000000000000001e-08 w=4.0000000000000003e-07
MN820 inv_818 cout_813 0 0 NMOS l=6.000000000000001e-08 w=2.0000000000000002e-07
MP822 inv_821 inv_818 VDD VDD PMOS l=6.000000000000001e-08 w=4.0000000000000003e-07
MN823 inv_821 inv_818 0 0 NMOS l=6.000000000000001e-08 w=2.0000000000000002e-07
MP825 inv_824 inv_616 VDD VDD PMOS l=6.000000000000001e-08 w=4.0000000000000003e-07
MN826 inv_824 inv_616 0 0 NMOS l=6.000000000000001e-08 w=2.0000000000000002e-07
MP828 inv_827 xor_625 VDD VDD PMOS l=6.000000000000001e-08 w=4.0000000000000003e-07
MN829 inv_827 xor_625 0 0 NMOS l=6.000000000000001e-08 w=2.0000000000000002e-07
MN831 inv_616 inv_827 xor_830 0 NMOS l=6.000000000000001e-08 w=2.0000000000000002e-07
MP832 inv_616 xor_625 xor_830 VDD PMOS l=6.000000000000001e-08 w=4.0000000000000003e-07
MN833 inv_824 xor_625 xor_830 0 NMOS l=6.000000000000001e-08 w=2.0000000000000002e-07
MP834 inv_824 inv_827 xor_830 VDD PMOS l=6.000000000000001e-08 w=4.0000000000000003e-07
MP836 inv_835 xor_830 VDD VDD PMOS l=6.000000000000001e-08 w=4.0000000000000003e-07
MN837 inv_835 xor_830 0 0 NMOS l=6.000000000000001e-08 w=2.0000000000000002e-07
MP839 inv_838 inv_821 VDD VDD PMOS l=6.000000000000001e-08 w=4.0000000000000003e-07
MN840 inv_838 inv_821 0 0 NMOS l=6.000000000000001e-08 w=2.0000000000000002e-07
MN842 xor_830 inv_838 xor_841 0 NMOS l=6.000000000000001e-08 w=2.0000000000000002e-07
MP843 xor_830 inv_821 xor_841 VDD PMOS l=6.000000000000001e-08 w=4.0000000000000003e-07
MN844 inv_835 inv_821 xor_841 0 NMOS l=6.000000000000001e-08 w=2.0000000000000002e-07
MP845 inv_835 inv_838 xor_841 VDD PMOS l=6.000000000000001e-08 w=4.0000000000000003e-07
MN847 inv_821 xor_830 cout_846 0 NMOS l=6.000000000000001e-08 w=2.0000000000000002e-07
MP848 inv_821 inv_835 cout_846 VDD PMOS l=6.000000000000001e-08 w=4.0000000000000003e-07
MN849 inv_616 inv_835 cout_846 0 NMOS l=6.000000000000001e-08 w=2.0000000000000002e-07
MP850 inv_616 xor_830 cout_846 VDD PMOS l=6.000000000000001e-08 w=4.0000000000000003e-07
MP852 inv_851 cout_846 VDD VDD PMOS l=6.000000000000001e-08 w=4.0000000000000003e-07
MN853 inv_851 cout_846 0 0 NMOS l=6.000000000000001e-08 w=2.0000000000000002e-07
MP855 inv_854 inv_851 VDD VDD PMOS l=6.000000000000001e-08 w=4.0000000000000003e-07
MN856 inv_854 inv_851 0 0 NMOS l=6.000000000000001e-08 w=2.0000000000000002e-07
MP858 inv_857 inv_636 VDD VDD PMOS l=6.000000000000001e-08 w=4.0000000000000003e-07
MN859 inv_857 inv_636 0 0 NMOS l=6.000000000000001e-08 w=2.0000000000000002e-07
MP861 inv_860 xor_645 VDD VDD PMOS l=6.000000000000001e-08 w=4.0000000000000003e-07
MN862 inv_860 xor_645 0 0 NMOS l=6.000000000000001e-08 w=2.0000000000000002e-07
MN864 inv_636 inv_860 xor_863 0 NMOS l=6.000000000000001e-08 w=2.0000000000000002e-07
MP865 inv_636 xor_645 xor_863 VDD PMOS l=6.000000000000001e-08 w=4.0000000000000003e-07
MN866 inv_857 xor_645 xor_863 0 NMOS l=6.000000000000001e-08 w=2.0000000000000002e-07
MP867 inv_857 inv_860 xor_863 VDD PMOS l=6.000000000000001e-08 w=4.0000000000000003e-07
MP869 inv_868 xor_863 VDD VDD PMOS l=6.000000000000001e-08 w=4.0000000000000003e-07
MN870 inv_868 xor_863 0 0 NMOS l=6.000000000000001e-08 w=2.0000000000000002e-07
MP872 inv_871 inv_854 VDD VDD PMOS l=6.000000000000001e-08 w=4.0000000000000003e-07
MN873 inv_871 inv_854 0 0 NMOS l=6.000000000000001e-08 w=2.0000000000000002e-07
MN875 xor_863 inv_871 xor_874 0 NMOS l=6.000000000000001e-08 w=2.0000000000000002e-07
MP876 xor_863 inv_854 xor_874 VDD PMOS l=6.000000000000001e-08 w=4.0000000000000003e-07
MN877 inv_868 inv_854 xor_874 0 NMOS l=6.000000000000001e-08 w=2.0000000000000002e-07
MP878 inv_868 inv_871 xor_874 VDD PMOS l=6.000000000000001e-08 w=4.0000000000000003e-07
MN880 inv_854 xor_863 cout_879 0 NMOS l=6.000000000000001e-08 w=2.0000000000000002e-07
MP881 inv_854 inv_868 cout_879 VDD PMOS l=6.000000000000001e-08 w=4.0000000000000003e-07
MN882 inv_636 inv_868 cout_879 0 NMOS l=6.000000000000001e-08 w=2.0000000000000002e-07
MP883 inv_636 xor_863 cout_879 VDD PMOS l=6.000000000000001e-08 w=4.0000000000000003e-07
MP885 inv_884 cout_879 VDD VDD PMOS l=6.000000000000001e-08 w=4.0000000000000003e-07
MN886 inv_884 cout_879 0 0 NMOS l=6.000000000000001e-08 w=2.0000000000000002e-07
MP888 inv_887 inv_884 VDD VDD PMOS l=6.000000000000001e-08 w=4.0000000000000003e-07
MN889 inv_887 inv_884 0 0 NMOS l=6.000000000000001e-08 w=2.0000000000000002e-07
MP891 inv_890 inv_656 VDD VDD PMOS l=6.000000000000001e-08 w=4.0000000000000003e-07
MN892 inv_890 inv_656 0 0 NMOS l=6.000000000000001e-08 w=2.0000000000000002e-07
MP894 inv_893 GND VDD VDD PMOS l=6.000000000000001e-08 w=4.0000000000000003e-07
MN895 inv_893 GND 0 0 NMOS l=6.000000000000001e-08 w=2.0000000000000002e-07
MN897 inv_656 inv_893 xor_896 0 NMOS l=6.000000000000001e-08 w=2.0000000000000002e-07
MP898 inv_656 GND xor_896 VDD PMOS l=6.000000000000001e-08 w=4.0000000000000003e-07
MN899 inv_890 GND xor_896 0 NMOS l=6.000000000000001e-08 w=2.0000000000000002e-07
MP900 inv_890 inv_893 xor_896 VDD PMOS l=6.000000000000001e-08 w=4.0000000000000003e-07
MP902 inv_901 xor_896 VDD VDD PMOS l=6.000000000000001e-08 w=4.0000000000000003e-07
MN903 inv_901 xor_896 0 0 NMOS l=6.000000000000001e-08 w=2.0000000000000002e-07
MP905 inv_904 inv_887 VDD VDD PMOS l=6.000000000000001e-08 w=4.0000000000000003e-07
MN906 inv_904 inv_887 0 0 NMOS l=6.000000000000001e-08 w=2.0000000000000002e-07
MN908 xor_896 inv_904 xor_907 0 NMOS l=6.000000000000001e-08 w=2.0000000000000002e-07
MP909 xor_896 inv_887 xor_907 VDD PMOS l=6.000000000000001e-08 w=4.0000000000000003e-07
MN910 inv_901 inv_887 xor_907 0 NMOS l=6.000000000000001e-08 w=2.0000000000000002e-07
MP911 inv_901 inv_904 xor_907 VDD PMOS l=6.000000000000001e-08 w=4.0000000000000003e-07
MN913 inv_887 xor_896 cout_912 0 NMOS l=6.000000000000001e-08 w=2.0000000000000002e-07
MP914 inv_887 inv_901 cout_912 VDD PMOS l=6.000000000000001e-08 w=4.0000000000000003e-07
MN915 inv_656 inv_901 cout_912 0 NMOS l=6.000000000000001e-08 w=2.0000000000000002e-07
MP916 inv_656 xor_896 cout_912 VDD PMOS l=6.000000000000001e-08 w=4.0000000000000003e-07
MP918 inv_917 cout_912 VDD VDD PMOS l=6.000000000000001e-08 w=4.0000000000000003e-07
MN919 inv_917 cout_912 0 0 NMOS l=6.000000000000001e-08 w=2.0000000000000002e-07
MP921 inv_920 inv_917 VDD VDD PMOS l=6.000000000000001e-08 w=4.0000000000000003e-07
MN922 inv_920 inv_917 0 0 NMOS l=6.000000000000001e-08 w=2.0000000000000002e-07
MP924 inv_923 GND VDD VDD PMOS l=6.000000000000001e-08 w=4.0000000000000003e-07
MN925 inv_923 GND 0 0 NMOS l=6.000000000000001e-08 w=2.0000000000000002e-07
MP927 inv_926 GND VDD VDD PMOS l=6.000000000000001e-08 w=4.0000000000000003e-07
MN928 inv_926 GND 0 0 NMOS l=6.000000000000001e-08 w=2.0000000000000002e-07
MN930 0 inv_926 xor_929 0 NMOS l=6.000000000000001e-08 w=2.0000000000000002e-07
MP931 0 GND xor_929 VDD PMOS l=6.000000000000001e-08 w=4.0000000000000003e-07
MN932 inv_923 GND xor_929 0 NMOS l=6.000000000000001e-08 w=2.0000000000000002e-07
MP933 inv_923 inv_926 xor_929 VDD PMOS l=6.000000000000001e-08 w=4.0000000000000003e-07
MP935 inv_934 xor_929 VDD VDD PMOS l=6.000000000000001e-08 w=4.0000000000000003e-07
MN936 inv_934 xor_929 0 0 NMOS l=6.000000000000001e-08 w=2.0000000000000002e-07
MP938 inv_937 inv_920 VDD VDD PMOS l=6.000000000000001e-08 w=4.0000000000000003e-07
MN939 inv_937 inv_920 0 0 NMOS l=6.000000000000001e-08 w=2.0000000000000002e-07
MN941 xor_929 inv_937 xor_940 0 NMOS l=6.000000000000001e-08 w=2.0000000000000002e-07
MP942 xor_929 inv_920 xor_940 VDD PMOS l=6.000000000000001e-08 w=4.0000000000000003e-07
MN943 inv_934 inv_920 xor_940 0 NMOS l=6.000000000000001e-08 w=2.0000000000000002e-07
MP944 inv_934 inv_937 xor_940 VDD PMOS l=6.000000000000001e-08 w=4.0000000000000003e-07
MN946 inv_920 xor_929 cout_945 0 NMOS l=6.000000000000001e-08 w=2.0000000000000002e-07
MP947 inv_920 inv_934 cout_945 VDD PMOS l=6.000000000000001e-08 w=4.0000000000000003e-07
MN948 0 inv_934 cout_945 0 NMOS l=6.000000000000001e-08 w=2.0000000000000002e-07
MP949 0 xor_929 cout_945 VDD PMOS l=6.000000000000001e-08 w=4.0000000000000003e-07
MP951 inv_950 cout_945 VDD VDD PMOS l=6.000000000000001e-08 w=4.0000000000000003e-07
MN952 inv_950 cout_945 0 0 NMOS l=6.000000000000001e-08 w=2.0000000000000002e-07
MP954 inv_953 inv_950 VDD VDD PMOS l=6.000000000000001e-08 w=4.0000000000000003e-07
MN955 inv_953 inv_950 0 0 NMOS l=6.000000000000001e-08 w=2.0000000000000002e-07
MP957 inv_956 GND VDD VDD PMOS l=6.000000000000001e-08 w=4.0000000000000003e-07
MN958 inv_956 GND 0 0 NMOS l=6.000000000000001e-08 w=2.0000000000000002e-07
MP960 inv_959 GND VDD VDD PMOS l=6.000000000000001e-08 w=4.0000000000000003e-07
MN961 inv_959 GND 0 0 NMOS l=6.000000000000001e-08 w=2.0000000000000002e-07
MN963 0 inv_959 xor_962 0 NMOS l=6.000000000000001e-08 w=2.0000000000000002e-07
MP964 0 GND xor_962 VDD PMOS l=6.000000000000001e-08 w=4.0000000000000003e-07
MN965 inv_956 GND xor_962 0 NMOS l=6.000000000000001e-08 w=2.0000000000000002e-07
MP966 inv_956 inv_959 xor_962 VDD PMOS l=6.000000000000001e-08 w=4.0000000000000003e-07
MP968 inv_967 xor_962 VDD VDD PMOS l=6.000000000000001e-08 w=4.0000000000000003e-07
MN969 inv_967 xor_962 0 0 NMOS l=6.000000000000001e-08 w=2.0000000000000002e-07
MP971 inv_970 inv_953 VDD VDD PMOS l=6.000000000000001e-08 w=4.0000000000000003e-07
MN972 inv_970 inv_953 0 0 NMOS l=6.000000000000001e-08 w=2.0000000000000002e-07
MN974 xor_962 inv_970 xor_973 0 NMOS l=6.000000000000001e-08 w=2.0000000000000002e-07
MP975 xor_962 inv_953 xor_973 VDD PMOS l=6.000000000000001e-08 w=4.0000000000000003e-07
MN976 inv_967 inv_953 xor_973 0 NMOS l=6.000000000000001e-08 w=2.0000000000000002e-07
MP977 inv_967 inv_970 xor_973 VDD PMOS l=6.000000000000001e-08 w=4.0000000000000003e-07
MN979 inv_953 xor_962 cout_978 0 NMOS l=6.000000000000001e-08 w=2.0000000000000002e-07
MP980 inv_953 inv_967 cout_978 VDD PMOS l=6.000000000000001e-08 w=4.0000000000000003e-07
MN981 0 inv_967 cout_978 0 NMOS l=6.000000000000001e-08 w=2.0000000000000002e-07
MP982 0 xor_962 cout_978 VDD PMOS l=6.000000000000001e-08 w=4.0000000000000003e-07
MP984 inv_983 cout_978 VDD VDD PMOS l=6.000000000000001e-08 w=4.0000000000000003e-07
MN985 inv_983 cout_978 0 0 NMOS l=6.000000000000001e-08 w=2.0000000000000002e-07
MP987 inv_986 inv_983 VDD VDD PMOS l=6.000000000000001e-08 w=4.0000000000000003e-07
MN988 inv_986 inv_983 0 0 NMOS l=6.000000000000001e-08 w=2.0000000000000002e-07
MP990 inv_989 A3_4 VDD VDD PMOS l=6.000000000000001e-08 w=4.0000000000000003e-07
MN991 inv_989 A3_4 0 0 NMOS l=6.000000000000001e-08 w=2.0000000000000002e-07
MP993 inv_992 B3_12 VDD VDD PMOS l=6.000000000000001e-08 w=4.0000000000000003e-07
MN994 inv_992 B3_12 0 0 NMOS l=6.000000000000001e-08 w=2.0000000000000002e-07
MN996 A3_4 inv_992 xor_995 0 NMOS l=6.000000000000001e-08 w=2.0000000000000002e-07
MP997 A3_4 B3_12 xor_995 VDD PMOS l=6.000000000000001e-08 w=4.0000000000000003e-07
MN998 inv_989 B3_12 xor_995 0 NMOS l=6.000000000000001e-08 w=2.0000000000000002e-07
MP999 inv_989 inv_992 xor_995 VDD PMOS l=6.000000000000001e-08 w=4.0000000000000003e-07
MP1001 inv_1000 xor_995 VDD VDD PMOS l=6.000000000000001e-08 w=4.0000000000000003e-07
MN1002 inv_1000 xor_995 0 0 NMOS l=6.000000000000001e-08 w=2.0000000000000002e-07
MP1004 inv_1003 GND VDD VDD PMOS l=6.000000000000001e-08 w=4.0000000000000003e-07
MN1005 inv_1003 GND 0 0 NMOS l=6.000000000000001e-08 w=2.0000000000000002e-07
MN1007 xor_995 inv_1003 xor_1006 0 NMOS l=6.000000000000001e-08 w=2.0000000000000002e-07
MP1008 xor_995 GND xor_1006 VDD PMOS l=6.000000000000001e-08 w=4.0000000000000003e-07
MN1009 inv_1000 GND xor_1006 0 NMOS l=6.000000000000001e-08 w=2.0000000000000002e-07
MP1010 inv_1000 inv_1003 xor_1006 VDD PMOS l=6.000000000000001e-08 w=4.0000000000000003e-07
MN1012 0 xor_995 cout_1011 0 NMOS l=6.000000000000001e-08 w=2.0000000000000002e-07
MP1013 0 inv_1000 cout_1011 VDD PMOS l=6.000000000000001e-08 w=4.0000000000000003e-07
MN1014 A3_4 inv_1000 cout_1011 0 NMOS l=6.000000000000001e-08 w=2.0000000000000002e-07
MP1015 A3_4 xor_995 cout_1011 VDD PMOS l=6.000000000000001e-08 w=4.0000000000000003e-07
MP1017 inv_1016 cout_1011 VDD VDD PMOS l=6.000000000000001e-08 w=4.0000000000000003e-07
MN1018 inv_1016 cout_1011 0 0 NMOS l=6.000000000000001e-08 w=2.0000000000000002e-07
MP1020 inv_1019 inv_1016 VDD VDD PMOS l=6.000000000000001e-08 w=4.0000000000000003e-07
MN1021 inv_1019 inv_1016 0 0 NMOS l=6.000000000000001e-08 w=2.0000000000000002e-07
MP1023 inv_1022 A4_5 VDD VDD PMOS l=6.000000000000001e-08 w=4.0000000000000003e-07
MN1024 inv_1022 A4_5 0 0 NMOS l=6.000000000000001e-08 w=2.0000000000000002e-07
MP1026 inv_1025 B4_13 VDD VDD PMOS l=6.000000000000001e-08 w=4.0000000000000003e-07
MN1027 inv_1025 B4_13 0 0 NMOS l=6.000000000000001e-08 w=2.0000000000000002e-07
MN1029 A4_5 inv_1025 xor_1028 0 NMOS l=6.000000000000001e-08 w=2.0000000000000002e-07
MP1030 A4_5 B4_13 xor_1028 VDD PMOS l=6.000000000000001e-08 w=4.0000000000000003e-07
MN1031 inv_1022 B4_13 xor_1028 0 NMOS l=6.000000000000001e-08 w=2.0000000000000002e-07
MP1032 inv_1022 inv_1025 xor_1028 VDD PMOS l=6.000000000000001e-08 w=4.0000000000000003e-07
MP1034 inv_1033 xor_1028 VDD VDD PMOS l=6.000000000000001e-08 w=4.0000000000000003e-07
MN1035 inv_1033 xor_1028 0 0 NMOS l=6.000000000000001e-08 w=2.0000000000000002e-07
MP1037 inv_1036 inv_1019 VDD VDD PMOS l=6.000000000000001e-08 w=4.0000000000000003e-07
MN1038 inv_1036 inv_1019 0 0 NMOS l=6.000000000000001e-08 w=2.0000000000000002e-07
MN1040 xor_1028 inv_1036 xor_1039 0 NMOS l=6.000000000000001e-08 w=2.0000000000000002e-07
MP1041 xor_1028 inv_1019 xor_1039 VDD PMOS l=6.000000000000001e-08 w=4.0000000000000003e-07
MN1042 inv_1033 inv_1019 xor_1039 0 NMOS l=6.000000000000001e-08 w=2.0000000000000002e-07
MP1043 inv_1033 inv_1036 xor_1039 VDD PMOS l=6.000000000000001e-08 w=4.0000000000000003e-07
MN1045 inv_1019 xor_1028 cout_1044 0 NMOS l=6.000000000000001e-08 w=2.0000000000000002e-07
MP1046 inv_1019 inv_1033 cout_1044 VDD PMOS l=6.000000000000001e-08 w=4.0000000000000003e-07
MN1047 A4_5 inv_1033 cout_1044 0 NMOS l=6.000000000000001e-08 w=2.0000000000000002e-07
MP1048 A4_5 xor_1028 cout_1044 VDD PMOS l=6.000000000000001e-08 w=4.0000000000000003e-07
MP1050 inv_1049 cout_1044 VDD VDD PMOS l=6.000000000000001e-08 w=4.0000000000000003e-07
MN1051 inv_1049 cout_1044 0 0 NMOS l=6.000000000000001e-08 w=2.0000000000000002e-07
MP1053 inv_1052 inv_1049 VDD VDD PMOS l=6.000000000000001e-08 w=4.0000000000000003e-07
MN1054 inv_1052 inv_1049 0 0 NMOS l=6.000000000000001e-08 w=2.0000000000000002e-07
MP1056 inv_1055 A5_6 VDD VDD PMOS l=6.000000000000001e-08 w=4.0000000000000003e-07
MN1057 inv_1055 A5_6 0 0 NMOS l=6.000000000000001e-08 w=2.0000000000000002e-07
MP1059 inv_1058 B5_14 VDD VDD PMOS l=6.000000000000001e-08 w=4.0000000000000003e-07
MN1060 inv_1058 B5_14 0 0 NMOS l=6.000000000000001e-08 w=2.0000000000000002e-07
MN1062 A5_6 inv_1058 xor_1061 0 NMOS l=6.000000000000001e-08 w=2.0000000000000002e-07
MP1063 A5_6 B5_14 xor_1061 VDD PMOS l=6.000000000000001e-08 w=4.0000000000000003e-07
MN1064 inv_1055 B5_14 xor_1061 0 NMOS l=6.000000000000001e-08 w=2.0000000000000002e-07
MP1065 inv_1055 inv_1058 xor_1061 VDD PMOS l=6.000000000000001e-08 w=4.0000000000000003e-07
MP1067 inv_1066 xor_1061 VDD VDD PMOS l=6.000000000000001e-08 w=4.0000000000000003e-07
MN1068 inv_1066 xor_1061 0 0 NMOS l=6.000000000000001e-08 w=2.0000000000000002e-07
MP1070 inv_1069 inv_1052 VDD VDD PMOS l=6.000000000000001e-08 w=4.0000000000000003e-07
MN1071 inv_1069 inv_1052 0 0 NMOS l=6.000000000000001e-08 w=2.0000000000000002e-07
MN1073 xor_1061 inv_1069 xor_1072 0 NMOS l=6.000000000000001e-08 w=2.0000000000000002e-07
MP1074 xor_1061 inv_1052 xor_1072 VDD PMOS l=6.000000000000001e-08 w=4.0000000000000003e-07
MN1075 inv_1066 inv_1052 xor_1072 0 NMOS l=6.000000000000001e-08 w=2.0000000000000002e-07
MP1076 inv_1066 inv_1069 xor_1072 VDD PMOS l=6.000000000000001e-08 w=4.0000000000000003e-07
MN1078 inv_1052 xor_1061 cout_1077 0 NMOS l=6.000000000000001e-08 w=2.0000000000000002e-07
MP1079 inv_1052 inv_1066 cout_1077 VDD PMOS l=6.000000000000001e-08 w=4.0000000000000003e-07
MN1080 A5_6 inv_1066 cout_1077 0 NMOS l=6.000000000000001e-08 w=2.0000000000000002e-07
MP1081 A5_6 xor_1061 cout_1077 VDD PMOS l=6.000000000000001e-08 w=4.0000000000000003e-07
MP1083 inv_1082 cout_1077 VDD VDD PMOS l=6.000000000000001e-08 w=4.0000000000000003e-07
MN1084 inv_1082 cout_1077 0 0 NMOS l=6.000000000000001e-08 w=2.0000000000000002e-07
MP1086 inv_1085 inv_1082 VDD VDD PMOS l=6.000000000000001e-08 w=4.0000000000000003e-07
MN1087 inv_1085 inv_1082 0 0 NMOS l=6.000000000000001e-08 w=2.0000000000000002e-07
MP1089 inv_1088 A6_7 VDD VDD PMOS l=6.000000000000001e-08 w=4.0000000000000003e-07
MN1090 inv_1088 A6_7 0 0 NMOS l=6.000000000000001e-08 w=2.0000000000000002e-07
MP1092 inv_1091 B6_15 VDD VDD PMOS l=6.000000000000001e-08 w=4.0000000000000003e-07
MN1093 inv_1091 B6_15 0 0 NMOS l=6.000000000000001e-08 w=2.0000000000000002e-07
MN1095 A6_7 inv_1091 xor_1094 0 NMOS l=6.000000000000001e-08 w=2.0000000000000002e-07
MP1096 A6_7 B6_15 xor_1094 VDD PMOS l=6.000000000000001e-08 w=4.0000000000000003e-07
MN1097 inv_1088 B6_15 xor_1094 0 NMOS l=6.000000000000001e-08 w=2.0000000000000002e-07
MP1098 inv_1088 inv_1091 xor_1094 VDD PMOS l=6.000000000000001e-08 w=4.0000000000000003e-07
MP1100 inv_1099 xor_1094 VDD VDD PMOS l=6.000000000000001e-08 w=4.0000000000000003e-07
MN1101 inv_1099 xor_1094 0 0 NMOS l=6.000000000000001e-08 w=2.0000000000000002e-07
MP1103 inv_1102 inv_1085 VDD VDD PMOS l=6.000000000000001e-08 w=4.0000000000000003e-07
MN1104 inv_1102 inv_1085 0 0 NMOS l=6.000000000000001e-08 w=2.0000000000000002e-07
MN1106 xor_1094 inv_1102 xor_1105 0 NMOS l=6.000000000000001e-08 w=2.0000000000000002e-07
MP1107 xor_1094 inv_1085 xor_1105 VDD PMOS l=6.000000000000001e-08 w=4.0000000000000003e-07
MN1108 inv_1099 inv_1085 xor_1105 0 NMOS l=6.000000000000001e-08 w=2.0000000000000002e-07
MP1109 inv_1099 inv_1102 xor_1105 VDD PMOS l=6.000000000000001e-08 w=4.0000000000000003e-07
MN1111 inv_1085 xor_1094 cout_1110 0 NMOS l=6.000000000000001e-08 w=2.0000000000000002e-07
MP1112 inv_1085 inv_1099 cout_1110 VDD PMOS l=6.000000000000001e-08 w=4.0000000000000003e-07
MN1113 A6_7 inv_1099 cout_1110 0 NMOS l=6.000000000000001e-08 w=2.0000000000000002e-07
MP1114 A6_7 xor_1094 cout_1110 VDD PMOS l=6.000000000000001e-08 w=4.0000000000000003e-07
MP1116 inv_1115 cout_1110 VDD VDD PMOS l=6.000000000000001e-08 w=4.0000000000000003e-07
MN1117 inv_1115 cout_1110 0 0 NMOS l=6.000000000000001e-08 w=2.0000000000000002e-07
MP1119 inv_1118 inv_1115 VDD VDD PMOS l=6.000000000000001e-08 w=4.0000000000000003e-07
MN1120 inv_1118 inv_1115 0 0 NMOS l=6.000000000000001e-08 w=2.0000000000000002e-07
MP1122 inv_1121 GND VDD VDD PMOS l=6.000000000000001e-08 w=4.0000000000000003e-07
MN1123 inv_1121 GND 0 0 NMOS l=6.000000000000001e-08 w=2.0000000000000002e-07
MP1125 inv_1124 GND VDD VDD PMOS l=6.000000000000001e-08 w=4.0000000000000003e-07
MN1126 inv_1124 GND 0 0 NMOS l=6.000000000000001e-08 w=2.0000000000000002e-07
MN1128 0 inv_1124 xor_1127 0 NMOS l=6.000000000000001e-08 w=2.0000000000000002e-07
MP1129 0 GND xor_1127 VDD PMOS l=6.000000000000001e-08 w=4.0000000000000003e-07
MN1130 inv_1121 GND xor_1127 0 NMOS l=6.000000000000001e-08 w=2.0000000000000002e-07
MP1131 inv_1121 inv_1124 xor_1127 VDD PMOS l=6.000000000000001e-08 w=4.0000000000000003e-07
MP1133 inv_1132 xor_1127 VDD VDD PMOS l=6.000000000000001e-08 w=4.0000000000000003e-07
MN1134 inv_1132 xor_1127 0 0 NMOS l=6.000000000000001e-08 w=2.0000000000000002e-07
MP1136 inv_1135 inv_1118 VDD VDD PMOS l=6.000000000000001e-08 w=4.0000000000000003e-07
MN1137 inv_1135 inv_1118 0 0 NMOS l=6.000000000000001e-08 w=2.0000000000000002e-07
MN1139 xor_1127 inv_1135 xor_1138 0 NMOS l=6.000000000000001e-08 w=2.0000000000000002e-07
MP1140 xor_1127 inv_1118 xor_1138 VDD PMOS l=6.000000000000001e-08 w=4.0000000000000003e-07
MN1141 inv_1132 inv_1118 xor_1138 0 NMOS l=6.000000000000001e-08 w=2.0000000000000002e-07
MP1142 inv_1132 inv_1135 xor_1138 VDD PMOS l=6.000000000000001e-08 w=4.0000000000000003e-07
MN1144 inv_1118 xor_1127 cout_1143 0 NMOS l=6.000000000000001e-08 w=2.0000000000000002e-07
MP1145 inv_1118 inv_1132 cout_1143 VDD PMOS l=6.000000000000001e-08 w=4.0000000000000003e-07
MN1146 0 inv_1132 cout_1143 0 NMOS l=6.000000000000001e-08 w=2.0000000000000002e-07
MP1147 0 xor_1127 cout_1143 VDD PMOS l=6.000000000000001e-08 w=4.0000000000000003e-07
MP1149 inv_1148 cout_1143 VDD VDD PMOS l=6.000000000000001e-08 w=4.0000000000000003e-07
MN1150 inv_1148 cout_1143 0 0 NMOS l=6.000000000000001e-08 w=2.0000000000000002e-07
MP1152 inv_1151 inv_1148 VDD VDD PMOS l=6.000000000000001e-08 w=4.0000000000000003e-07
MN1153 inv_1151 inv_1148 0 0 NMOS l=6.000000000000001e-08 w=2.0000000000000002e-07
MP1155 inv_1154 xor_1006 VDD VDD PMOS l=6.000000000000001e-08 w=4.0000000000000003e-07
MN1156 inv_1154 xor_1006 0 0 NMOS l=6.000000000000001e-08 w=2.0000000000000002e-07
MP1158 inv_1157 GND VDD VDD PMOS l=6.000000000000001e-08 w=4.0000000000000003e-07
MN1159 inv_1157 GND 0 0 NMOS l=6.000000000000001e-08 w=2.0000000000000002e-07
MN1161 xor_1006 inv_1157 xor_1160 0 NMOS l=6.000000000000001e-08 w=2.0000000000000002e-07
MP1162 xor_1006 GND xor_1160 VDD PMOS l=6.000000000000001e-08 w=4.0000000000000003e-07
MN1163 inv_1154 GND xor_1160 0 NMOS l=6.000000000000001e-08 w=2.0000000000000002e-07
MP1164 inv_1154 inv_1157 xor_1160 VDD PMOS l=6.000000000000001e-08 w=4.0000000000000003e-07
MP1166 inv_1165 xor_1160 VDD VDD PMOS l=6.000000000000001e-08 w=4.0000000000000003e-07
MN1167 inv_1165 xor_1160 0 0 NMOS l=6.000000000000001e-08 w=2.0000000000000002e-07
MP1169 inv_1168 GND VDD VDD PMOS l=6.000000000000001e-08 w=4.0000000000000003e-07
MN1170 inv_1168 GND 0 0 NMOS l=6.000000000000001e-08 w=2.0000000000000002e-07
MN1172 xor_1160 inv_1168 xor_1171 0 NMOS l=6.000000000000001e-08 w=2.0000000000000002e-07
MP1173 xor_1160 GND xor_1171 VDD PMOS l=6.000000000000001e-08 w=4.0000000000000003e-07
MN1174 inv_1165 GND xor_1171 0 NMOS l=6.000000000000001e-08 w=2.0000000000000002e-07
MP1175 inv_1165 inv_1168 xor_1171 VDD PMOS l=6.000000000000001e-08 w=4.0000000000000003e-07
MN1177 0 xor_1160 cout_1176 0 NMOS l=6.000000000000001e-08 w=2.0000000000000002e-07
MP1178 0 inv_1165 cout_1176 VDD PMOS l=6.000000000000001e-08 w=4.0000000000000003e-07
MN1179 xor_1006 inv_1165 cout_1176 0 NMOS l=6.000000000000001e-08 w=2.0000000000000002e-07
MP1180 xor_1006 xor_1160 cout_1176 VDD PMOS l=6.000000000000001e-08 w=4.0000000000000003e-07
MP1182 inv_1181 cout_1176 VDD VDD PMOS l=6.000000000000001e-08 w=4.0000000000000003e-07
MN1183 inv_1181 cout_1176 0 0 NMOS l=6.000000000000001e-08 w=2.0000000000000002e-07
MP1185 inv_1184 inv_1181 VDD VDD PMOS l=6.000000000000001e-08 w=4.0000000000000003e-07
MN1186 inv_1184 inv_1181 0 0 NMOS l=6.000000000000001e-08 w=2.0000000000000002e-07
MP1188 inv_1187 xor_1039 VDD VDD PMOS l=6.000000000000001e-08 w=4.0000000000000003e-07
MN1189 inv_1187 xor_1039 0 0 NMOS l=6.000000000000001e-08 w=2.0000000000000002e-07
MP1191 inv_1190 GND VDD VDD PMOS l=6.000000000000001e-08 w=4.0000000000000003e-07
MN1192 inv_1190 GND 0 0 NMOS l=6.000000000000001e-08 w=2.0000000000000002e-07
MN1194 xor_1039 inv_1190 xor_1193 0 NMOS l=6.000000000000001e-08 w=2.0000000000000002e-07
MP1195 xor_1039 GND xor_1193 VDD PMOS l=6.000000000000001e-08 w=4.0000000000000003e-07
MN1196 inv_1187 GND xor_1193 0 NMOS l=6.000000000000001e-08 w=2.0000000000000002e-07
MP1197 inv_1187 inv_1190 xor_1193 VDD PMOS l=6.000000000000001e-08 w=4.0000000000000003e-07
MP1199 inv_1198 xor_1193 VDD VDD PMOS l=6.000000000000001e-08 w=4.0000000000000003e-07
MN1200 inv_1198 xor_1193 0 0 NMOS l=6.000000000000001e-08 w=2.0000000000000002e-07
MP1202 inv_1201 inv_1184 VDD VDD PMOS l=6.000000000000001e-08 w=4.0000000000000003e-07
MN1203 inv_1201 inv_1184 0 0 NMOS l=6.000000000000001e-08 w=2.0000000000000002e-07
MN1205 xor_1193 inv_1201 xor_1204 0 NMOS l=6.000000000000001e-08 w=2.0000000000000002e-07
MP1206 xor_1193 inv_1184 xor_1204 VDD PMOS l=6.000000000000001e-08 w=4.0000000000000003e-07
MN1207 inv_1198 inv_1184 xor_1204 0 NMOS l=6.000000000000001e-08 w=2.0000000000000002e-07
MP1208 inv_1198 inv_1201 xor_1204 VDD PMOS l=6.000000000000001e-08 w=4.0000000000000003e-07
MN1210 inv_1184 xor_1193 cout_1209 0 NMOS l=6.000000000000001e-08 w=2.0000000000000002e-07
MP1211 inv_1184 inv_1198 cout_1209 VDD PMOS l=6.000000000000001e-08 w=4.0000000000000003e-07
MN1212 xor_1039 inv_1198 cout_1209 0 NMOS l=6.000000000000001e-08 w=2.0000000000000002e-07
MP1213 xor_1039 xor_1193 cout_1209 VDD PMOS l=6.000000000000001e-08 w=4.0000000000000003e-07
MP1215 inv_1214 cout_1209 VDD VDD PMOS l=6.000000000000001e-08 w=4.0000000000000003e-07
MN1216 inv_1214 cout_1209 0 0 NMOS l=6.000000000000001e-08 w=2.0000000000000002e-07
MP1218 inv_1217 inv_1214 VDD VDD PMOS l=6.000000000000001e-08 w=4.0000000000000003e-07
MN1219 inv_1217 inv_1214 0 0 NMOS l=6.000000000000001e-08 w=2.0000000000000002e-07
MP1221 inv_1220 xor_1072 VDD VDD PMOS l=6.000000000000001e-08 w=4.0000000000000003e-07
MN1222 inv_1220 xor_1072 0 0 NMOS l=6.000000000000001e-08 w=2.0000000000000002e-07
MP1224 inv_1223 GND VDD VDD PMOS l=6.000000000000001e-08 w=4.0000000000000003e-07
MN1225 inv_1223 GND 0 0 NMOS l=6.000000000000001e-08 w=2.0000000000000002e-07
MN1227 xor_1072 inv_1223 xor_1226 0 NMOS l=6.000000000000001e-08 w=2.0000000000000002e-07
MP1228 xor_1072 GND xor_1226 VDD PMOS l=6.000000000000001e-08 w=4.0000000000000003e-07
MN1229 inv_1220 GND xor_1226 0 NMOS l=6.000000000000001e-08 w=2.0000000000000002e-07
MP1230 inv_1220 inv_1223 xor_1226 VDD PMOS l=6.000000000000001e-08 w=4.0000000000000003e-07
MP1232 inv_1231 xor_1226 VDD VDD PMOS l=6.000000000000001e-08 w=4.0000000000000003e-07
MN1233 inv_1231 xor_1226 0 0 NMOS l=6.000000000000001e-08 w=2.0000000000000002e-07
MP1235 inv_1234 inv_1217 VDD VDD PMOS l=6.000000000000001e-08 w=4.0000000000000003e-07
MN1236 inv_1234 inv_1217 0 0 NMOS l=6.000000000000001e-08 w=2.0000000000000002e-07
MN1238 xor_1226 inv_1234 xor_1237 0 NMOS l=6.000000000000001e-08 w=2.0000000000000002e-07
MP1239 xor_1226 inv_1217 xor_1237 VDD PMOS l=6.000000000000001e-08 w=4.0000000000000003e-07
MN1240 inv_1231 inv_1217 xor_1237 0 NMOS l=6.000000000000001e-08 w=2.0000000000000002e-07
MP1241 inv_1231 inv_1234 xor_1237 VDD PMOS l=6.000000000000001e-08 w=4.0000000000000003e-07
MN1243 inv_1217 xor_1226 cout_1242 0 NMOS l=6.000000000000001e-08 w=2.0000000000000002e-07
MP1244 inv_1217 inv_1231 cout_1242 VDD PMOS l=6.000000000000001e-08 w=4.0000000000000003e-07
MN1245 xor_1072 inv_1231 cout_1242 0 NMOS l=6.000000000000001e-08 w=2.0000000000000002e-07
MP1246 xor_1072 xor_1226 cout_1242 VDD PMOS l=6.000000000000001e-08 w=4.0000000000000003e-07
MP1248 inv_1247 cout_1242 VDD VDD PMOS l=6.000000000000001e-08 w=4.0000000000000003e-07
MN1249 inv_1247 cout_1242 0 0 NMOS l=6.000000000000001e-08 w=2.0000000000000002e-07
MP1251 inv_1250 inv_1247 VDD VDD PMOS l=6.000000000000001e-08 w=4.0000000000000003e-07
MN1252 inv_1250 inv_1247 0 0 NMOS l=6.000000000000001e-08 w=2.0000000000000002e-07
MP1254 inv_1253 xor_1105 VDD VDD PMOS l=6.000000000000001e-08 w=4.0000000000000003e-07
MN1255 inv_1253 xor_1105 0 0 NMOS l=6.000000000000001e-08 w=2.0000000000000002e-07
MP1257 inv_1256 VDD VDD VDD PMOS l=6.000000000000001e-08 w=4.0000000000000003e-07
MN1258 inv_1256 VDD 0 0 NMOS l=6.000000000000001e-08 w=2.0000000000000002e-07
MN1260 xor_1105 inv_1256 xor_1259 0 NMOS l=6.000000000000001e-08 w=2.0000000000000002e-07
MP1261 xor_1105 VDD xor_1259 VDD PMOS l=6.000000000000001e-08 w=4.0000000000000003e-07
MN1262 inv_1253 VDD xor_1259 0 NMOS l=6.000000000000001e-08 w=2.0000000000000002e-07
MP1263 inv_1253 inv_1256 xor_1259 VDD PMOS l=6.000000000000001e-08 w=4.0000000000000003e-07
MP1265 inv_1264 xor_1259 VDD VDD PMOS l=6.000000000000001e-08 w=4.0000000000000003e-07
MN1266 inv_1264 xor_1259 0 0 NMOS l=6.000000000000001e-08 w=2.0000000000000002e-07
MP1268 inv_1267 inv_1250 VDD VDD PMOS l=6.000000000000001e-08 w=4.0000000000000003e-07
MN1269 inv_1267 inv_1250 0 0 NMOS l=6.000000000000001e-08 w=2.0000000000000002e-07
MN1271 xor_1259 inv_1267 xor_1270 0 NMOS l=6.000000000000001e-08 w=2.0000000000000002e-07
MP1272 xor_1259 inv_1250 xor_1270 VDD PMOS l=6.000000000000001e-08 w=4.0000000000000003e-07
MN1273 inv_1264 inv_1250 xor_1270 0 NMOS l=6.000000000000001e-08 w=2.0000000000000002e-07
MP1274 inv_1264 inv_1267 xor_1270 VDD PMOS l=6.000000000000001e-08 w=4.0000000000000003e-07
MN1276 inv_1250 xor_1259 cout_1275 0 NMOS l=6.000000000000001e-08 w=2.0000000000000002e-07
MP1277 inv_1250 inv_1264 cout_1275 VDD PMOS l=6.000000000000001e-08 w=4.0000000000000003e-07
MN1278 xor_1105 inv_1264 cout_1275 0 NMOS l=6.000000000000001e-08 w=2.0000000000000002e-07
MP1279 xor_1105 xor_1259 cout_1275 VDD PMOS l=6.000000000000001e-08 w=4.0000000000000003e-07
MP1281 inv_1280 cout_1275 VDD VDD PMOS l=6.000000000000001e-08 w=4.0000000000000003e-07
MN1282 inv_1280 cout_1275 0 0 NMOS l=6.000000000000001e-08 w=2.0000000000000002e-07
MP1284 inv_1283 inv_1280 VDD VDD PMOS l=6.000000000000001e-08 w=4.0000000000000003e-07
MN1285 inv_1283 inv_1280 0 0 NMOS l=6.000000000000001e-08 w=2.0000000000000002e-07
MP1287 inv_1286 xor_1138 VDD VDD PMOS l=6.000000000000001e-08 w=4.0000000000000003e-07
MN1288 inv_1286 xor_1138 0 0 NMOS l=6.000000000000001e-08 w=2.0000000000000002e-07
MP1290 inv_1289 VDD VDD VDD PMOS l=6.000000000000001e-08 w=4.0000000000000003e-07
MN1291 inv_1289 VDD 0 0 NMOS l=6.000000000000001e-08 w=2.0000000000000002e-07
MN1293 xor_1138 inv_1289 xor_1292 0 NMOS l=6.000000000000001e-08 w=2.0000000000000002e-07
MP1294 xor_1138 VDD xor_1292 VDD PMOS l=6.000000000000001e-08 w=4.0000000000000003e-07
MN1295 inv_1286 VDD xor_1292 0 NMOS l=6.000000000000001e-08 w=2.0000000000000002e-07
MP1296 inv_1286 inv_1289 xor_1292 VDD PMOS l=6.000000000000001e-08 w=4.0000000000000003e-07
MP1298 inv_1297 xor_1292 VDD VDD PMOS l=6.000000000000001e-08 w=4.0000000000000003e-07
MN1299 inv_1297 xor_1292 0 0 NMOS l=6.000000000000001e-08 w=2.0000000000000002e-07
MP1301 inv_1300 inv_1283 VDD VDD PMOS l=6.000000000000001e-08 w=4.0000000000000003e-07
MN1302 inv_1300 inv_1283 0 0 NMOS l=6.000000000000001e-08 w=2.0000000000000002e-07
MN1304 xor_1292 inv_1300 xor_1303 0 NMOS l=6.000000000000001e-08 w=2.0000000000000002e-07
MP1305 xor_1292 inv_1283 xor_1303 VDD PMOS l=6.000000000000001e-08 w=4.0000000000000003e-07
MN1306 inv_1297 inv_1283 xor_1303 0 NMOS l=6.000000000000001e-08 w=2.0000000000000002e-07
MP1307 inv_1297 inv_1300 xor_1303 VDD PMOS l=6.000000000000001e-08 w=4.0000000000000003e-07
MN1309 inv_1283 xor_1292 cout_1308 0 NMOS l=6.000000000000001e-08 w=2.0000000000000002e-07
MP1310 inv_1283 inv_1297 cout_1308 VDD PMOS l=6.000000000000001e-08 w=4.0000000000000003e-07
MN1311 xor_1138 inv_1297 cout_1308 0 NMOS l=6.000000000000001e-08 w=2.0000000000000002e-07
MP1312 xor_1138 xor_1292 cout_1308 VDD PMOS l=6.000000000000001e-08 w=4.0000000000000003e-07
MP1314 inv_1313 cout_1308 VDD VDD PMOS l=6.000000000000001e-08 w=4.0000000000000003e-07
MN1315 inv_1313 cout_1308 0 0 NMOS l=6.000000000000001e-08 w=2.0000000000000002e-07
MP1317 inv_1316 inv_1313 VDD VDD PMOS l=6.000000000000001e-08 w=4.0000000000000003e-07
MN1318 inv_1316 inv_1313 0 0 NMOS l=6.000000000000001e-08 w=2.0000000000000002e-07
MP1320 inv_1319 inv_1316 VDD VDD PMOS l=6.000000000000001e-08 w=4.0000000000000003e-07
MN1321 inv_1319 inv_1316 0 0 NMOS l=6.000000000000001e-08 w=2.0000000000000002e-07
MP1323 inv_1322 xor_1006 VDD VDD PMOS l=6.000000000000001e-08 w=4.0000000000000003e-07
MN1324 inv_1322 xor_1006 0 0 NMOS l=6.000000000000001e-08 w=2.0000000000000002e-07
MP1326 inv_1325 GND VDD VDD PMOS l=6.000000000000001e-08 w=4.0000000000000003e-07
MN1327 inv_1325 GND 0 0 NMOS l=6.000000000000001e-08 w=2.0000000000000002e-07
MN1329 xor_1006 inv_1325 xor_1328 0 NMOS l=6.000000000000001e-08 w=2.0000000000000002e-07
MP1330 xor_1006 GND xor_1328 VDD PMOS l=6.000000000000001e-08 w=4.0000000000000003e-07
MN1331 inv_1322 GND xor_1328 0 NMOS l=6.000000000000001e-08 w=2.0000000000000002e-07
MP1332 inv_1322 inv_1325 xor_1328 VDD PMOS l=6.000000000000001e-08 w=4.0000000000000003e-07
MP1334 inv_1333 xor_1328 VDD VDD PMOS l=6.000000000000001e-08 w=4.0000000000000003e-07
MN1335 inv_1333 xor_1328 0 0 NMOS l=6.000000000000001e-08 w=2.0000000000000002e-07
MP1337 inv_1336 GND VDD VDD PMOS l=6.000000000000001e-08 w=4.0000000000000003e-07
MN1338 inv_1336 GND 0 0 NMOS l=6.000000000000001e-08 w=2.0000000000000002e-07
MN1340 xor_1328 inv_1336 xor_1339 0 NMOS l=6.000000000000001e-08 w=2.0000000000000002e-07
MP1341 xor_1328 GND xor_1339 VDD PMOS l=6.000000000000001e-08 w=4.0000000000000003e-07
MN1342 inv_1333 GND xor_1339 0 NMOS l=6.000000000000001e-08 w=2.0000000000000002e-07
MP1343 inv_1333 inv_1336 xor_1339 VDD PMOS l=6.000000000000001e-08 w=4.0000000000000003e-07
MN1345 0 xor_1328 cout_1344 0 NMOS l=6.000000000000001e-08 w=2.0000000000000002e-07
MP1346 0 inv_1333 cout_1344 VDD PMOS l=6.000000000000001e-08 w=4.0000000000000003e-07
MN1347 xor_1006 inv_1333 cout_1344 0 NMOS l=6.000000000000001e-08 w=2.0000000000000002e-07
MP1348 xor_1006 xor_1328 cout_1344 VDD PMOS l=6.000000000000001e-08 w=4.0000000000000003e-07
MP1350 inv_1349 cout_1344 VDD VDD PMOS l=6.000000000000001e-08 w=4.0000000000000003e-07
MN1351 inv_1349 cout_1344 0 0 NMOS l=6.000000000000001e-08 w=2.0000000000000002e-07
MP1353 inv_1352 inv_1349 VDD VDD PMOS l=6.000000000000001e-08 w=4.0000000000000003e-07
MN1354 inv_1352 inv_1349 0 0 NMOS l=6.000000000000001e-08 w=2.0000000000000002e-07
MP1356 inv_1355 xor_1039 VDD VDD PMOS l=6.000000000000001e-08 w=4.0000000000000003e-07
MN1357 inv_1355 xor_1039 0 0 NMOS l=6.000000000000001e-08 w=2.0000000000000002e-07
MP1359 inv_1358 VDD VDD VDD PMOS l=6.000000000000001e-08 w=4.0000000000000003e-07
MN1360 inv_1358 VDD 0 0 NMOS l=6.000000000000001e-08 w=2.0000000000000002e-07
MN1362 xor_1039 inv_1358 xor_1361 0 NMOS l=6.000000000000001e-08 w=2.0000000000000002e-07
MP1363 xor_1039 VDD xor_1361 VDD PMOS l=6.000000000000001e-08 w=4.0000000000000003e-07
MN1364 inv_1355 VDD xor_1361 0 NMOS l=6.000000000000001e-08 w=2.0000000000000002e-07
MP1365 inv_1355 inv_1358 xor_1361 VDD PMOS l=6.000000000000001e-08 w=4.0000000000000003e-07
MP1367 inv_1366 xor_1361 VDD VDD PMOS l=6.000000000000001e-08 w=4.0000000000000003e-07
MN1368 inv_1366 xor_1361 0 0 NMOS l=6.000000000000001e-08 w=2.0000000000000002e-07
MP1370 inv_1369 inv_1352 VDD VDD PMOS l=6.000000000000001e-08 w=4.0000000000000003e-07
MN1371 inv_1369 inv_1352 0 0 NMOS l=6.000000000000001e-08 w=2.0000000000000002e-07
MN1373 xor_1361 inv_1369 xor_1372 0 NMOS l=6.000000000000001e-08 w=2.0000000000000002e-07
MP1374 xor_1361 inv_1352 xor_1372 VDD PMOS l=6.000000000000001e-08 w=4.0000000000000003e-07
MN1375 inv_1366 inv_1352 xor_1372 0 NMOS l=6.000000000000001e-08 w=2.0000000000000002e-07
MP1376 inv_1366 inv_1369 xor_1372 VDD PMOS l=6.000000000000001e-08 w=4.0000000000000003e-07
MN1378 inv_1352 xor_1361 cout_1377 0 NMOS l=6.000000000000001e-08 w=2.0000000000000002e-07
MP1379 inv_1352 inv_1366 cout_1377 VDD PMOS l=6.000000000000001e-08 w=4.0000000000000003e-07
MN1380 xor_1039 inv_1366 cout_1377 0 NMOS l=6.000000000000001e-08 w=2.0000000000000002e-07
MP1381 xor_1039 xor_1361 cout_1377 VDD PMOS l=6.000000000000001e-08 w=4.0000000000000003e-07
MP1383 inv_1382 cout_1377 VDD VDD PMOS l=6.000000000000001e-08 w=4.0000000000000003e-07
MN1384 inv_1382 cout_1377 0 0 NMOS l=6.000000000000001e-08 w=2.0000000000000002e-07
MP1386 inv_1385 inv_1382 VDD VDD PMOS l=6.000000000000001e-08 w=4.0000000000000003e-07
MN1387 inv_1385 inv_1382 0 0 NMOS l=6.000000000000001e-08 w=2.0000000000000002e-07
MP1389 inv_1388 xor_1072 VDD VDD PMOS l=6.000000000000001e-08 w=4.0000000000000003e-07
MN1390 inv_1388 xor_1072 0 0 NMOS l=6.000000000000001e-08 w=2.0000000000000002e-07
MP1392 inv_1391 GND VDD VDD PMOS l=6.000000000000001e-08 w=4.0000000000000003e-07
MN1393 inv_1391 GND 0 0 NMOS l=6.000000000000001e-08 w=2.0000000000000002e-07
MN1395 xor_1072 inv_1391 xor_1394 0 NMOS l=6.000000000000001e-08 w=2.0000000000000002e-07
MP1396 xor_1072 GND xor_1394 VDD PMOS l=6.000000000000001e-08 w=4.0000000000000003e-07
MN1397 inv_1388 GND xor_1394 0 NMOS l=6.000000000000001e-08 w=2.0000000000000002e-07
MP1398 inv_1388 inv_1391 xor_1394 VDD PMOS l=6.000000000000001e-08 w=4.0000000000000003e-07
MP1400 inv_1399 xor_1394 VDD VDD PMOS l=6.000000000000001e-08 w=4.0000000000000003e-07
MN1401 inv_1399 xor_1394 0 0 NMOS l=6.000000000000001e-08 w=2.0000000000000002e-07
MP1403 inv_1402 inv_1385 VDD VDD PMOS l=6.000000000000001e-08 w=4.0000000000000003e-07
MN1404 inv_1402 inv_1385 0 0 NMOS l=6.000000000000001e-08 w=2.0000000000000002e-07
MN1406 xor_1394 inv_1402 xor_1405 0 NMOS l=6.000000000000001e-08 w=2.0000000000000002e-07
MP1407 xor_1394 inv_1385 xor_1405 VDD PMOS l=6.000000000000001e-08 w=4.0000000000000003e-07
MN1408 inv_1399 inv_1385 xor_1405 0 NMOS l=6.000000000000001e-08 w=2.0000000000000002e-07
MP1409 inv_1399 inv_1402 xor_1405 VDD PMOS l=6.000000000000001e-08 w=4.0000000000000003e-07
MN1411 inv_1385 xor_1394 cout_1410 0 NMOS l=6.000000000000001e-08 w=2.0000000000000002e-07
MP1412 inv_1385 inv_1399 cout_1410 VDD PMOS l=6.000000000000001e-08 w=4.0000000000000003e-07
MN1413 xor_1072 inv_1399 cout_1410 0 NMOS l=6.000000000000001e-08 w=2.0000000000000002e-07
MP1414 xor_1072 xor_1394 cout_1410 VDD PMOS l=6.000000000000001e-08 w=4.0000000000000003e-07
MP1416 inv_1415 cout_1410 VDD VDD PMOS l=6.000000000000001e-08 w=4.0000000000000003e-07
MN1417 inv_1415 cout_1410 0 0 NMOS l=6.000000000000001e-08 w=2.0000000000000002e-07
MP1419 inv_1418 inv_1415 VDD VDD PMOS l=6.000000000000001e-08 w=4.0000000000000003e-07
MN1420 inv_1418 inv_1415 0 0 NMOS l=6.000000000000001e-08 w=2.0000000000000002e-07
MP1422 inv_1421 xor_1105 VDD VDD PMOS l=6.000000000000001e-08 w=4.0000000000000003e-07
MN1423 inv_1421 xor_1105 0 0 NMOS l=6.000000000000001e-08 w=2.0000000000000002e-07
MP1425 inv_1424 VDD VDD VDD PMOS l=6.000000000000001e-08 w=4.0000000000000003e-07
MN1426 inv_1424 VDD 0 0 NMOS l=6.000000000000001e-08 w=2.0000000000000002e-07
MN1428 xor_1105 inv_1424 xor_1427 0 NMOS l=6.000000000000001e-08 w=2.0000000000000002e-07
MP1429 xor_1105 VDD xor_1427 VDD PMOS l=6.000000000000001e-08 w=4.0000000000000003e-07
MN1430 inv_1421 VDD xor_1427 0 NMOS l=6.000000000000001e-08 w=2.0000000000000002e-07
MP1431 inv_1421 inv_1424 xor_1427 VDD PMOS l=6.000000000000001e-08 w=4.0000000000000003e-07
MP1433 inv_1432 xor_1427 VDD VDD PMOS l=6.000000000000001e-08 w=4.0000000000000003e-07
MN1434 inv_1432 xor_1427 0 0 NMOS l=6.000000000000001e-08 w=2.0000000000000002e-07
MP1436 inv_1435 inv_1418 VDD VDD PMOS l=6.000000000000001e-08 w=4.0000000000000003e-07
MN1437 inv_1435 inv_1418 0 0 NMOS l=6.000000000000001e-08 w=2.0000000000000002e-07
MN1439 xor_1427 inv_1435 xor_1438 0 NMOS l=6.000000000000001e-08 w=2.0000000000000002e-07
MP1440 xor_1427 inv_1418 xor_1438 VDD PMOS l=6.000000000000001e-08 w=4.0000000000000003e-07
MN1441 inv_1432 inv_1418 xor_1438 0 NMOS l=6.000000000000001e-08 w=2.0000000000000002e-07
MP1442 inv_1432 inv_1435 xor_1438 VDD PMOS l=6.000000000000001e-08 w=4.0000000000000003e-07
MN1444 inv_1418 xor_1427 cout_1443 0 NMOS l=6.000000000000001e-08 w=2.0000000000000002e-07
MP1445 inv_1418 inv_1432 cout_1443 VDD PMOS l=6.000000000000001e-08 w=4.0000000000000003e-07
MN1446 xor_1105 inv_1432 cout_1443 0 NMOS l=6.000000000000001e-08 w=2.0000000000000002e-07
MP1447 xor_1105 xor_1427 cout_1443 VDD PMOS l=6.000000000000001e-08 w=4.0000000000000003e-07
MP1449 inv_1448 cout_1443 VDD VDD PMOS l=6.000000000000001e-08 w=4.0000000000000003e-07
MN1450 inv_1448 cout_1443 0 0 NMOS l=6.000000000000001e-08 w=2.0000000000000002e-07
MP1452 inv_1451 inv_1448 VDD VDD PMOS l=6.000000000000001e-08 w=4.0000000000000003e-07
MN1453 inv_1451 inv_1448 0 0 NMOS l=6.000000000000001e-08 w=2.0000000000000002e-07
MP1455 inv_1454 xor_1138 VDD VDD PMOS l=6.000000000000001e-08 w=4.0000000000000003e-07
MN1456 inv_1454 xor_1138 0 0 NMOS l=6.000000000000001e-08 w=2.0000000000000002e-07
MP1458 inv_1457 GND VDD VDD PMOS l=6.000000000000001e-08 w=4.0000000000000003e-07
MN1459 inv_1457 GND 0 0 NMOS l=6.000000000000001e-08 w=2.0000000000000002e-07
MN1461 xor_1138 inv_1457 xor_1460 0 NMOS l=6.000000000000001e-08 w=2.0000000000000002e-07
MP1462 xor_1138 GND xor_1460 VDD PMOS l=6.000000000000001e-08 w=4.0000000000000003e-07
MN1463 inv_1454 GND xor_1460 0 NMOS l=6.000000000000001e-08 w=2.0000000000000002e-07
MP1464 inv_1454 inv_1457 xor_1460 VDD PMOS l=6.000000000000001e-08 w=4.0000000000000003e-07
MP1466 inv_1465 xor_1460 VDD VDD PMOS l=6.000000000000001e-08 w=4.0000000000000003e-07
MN1467 inv_1465 xor_1460 0 0 NMOS l=6.000000000000001e-08 w=2.0000000000000002e-07
MP1469 inv_1468 inv_1451 VDD VDD PMOS l=6.000000000000001e-08 w=4.0000000000000003e-07
MN1470 inv_1468 inv_1451 0 0 NMOS l=6.000000000000001e-08 w=2.0000000000000002e-07
MN1472 xor_1460 inv_1468 xor_1471 0 NMOS l=6.000000000000001e-08 w=2.0000000000000002e-07
MP1473 xor_1460 inv_1451 xor_1471 VDD PMOS l=6.000000000000001e-08 w=4.0000000000000003e-07
MN1474 inv_1465 inv_1451 xor_1471 0 NMOS l=6.000000000000001e-08 w=2.0000000000000002e-07
MP1475 inv_1465 inv_1468 xor_1471 VDD PMOS l=6.000000000000001e-08 w=4.0000000000000003e-07
MN1477 inv_1451 xor_1460 cout_1476 0 NMOS l=6.000000000000001e-08 w=2.0000000000000002e-07
MP1478 inv_1451 inv_1465 cout_1476 VDD PMOS l=6.000000000000001e-08 w=4.0000000000000003e-07
MN1479 xor_1138 inv_1465 cout_1476 0 NMOS l=6.000000000000001e-08 w=2.0000000000000002e-07
MP1480 xor_1138 xor_1460 cout_1476 VDD PMOS l=6.000000000000001e-08 w=4.0000000000000003e-07
MP1482 inv_1481 cout_1476 VDD VDD PMOS l=6.000000000000001e-08 w=4.0000000000000003e-07
MN1483 inv_1481 cout_1476 0 0 NMOS l=6.000000000000001e-08 w=2.0000000000000002e-07
MP1485 inv_1484 inv_1481 VDD VDD PMOS l=6.000000000000001e-08 w=4.0000000000000003e-07
MN1486 inv_1484 inv_1481 0 0 NMOS l=6.000000000000001e-08 w=2.0000000000000002e-07
MP1488 inv_1487 GND VDD VDD PMOS l=6.000000000000001e-08 w=4.0000000000000003e-07
MN1489 inv_1487 GND 0 0 NMOS l=6.000000000000001e-08 w=2.0000000000000002e-07
MP1491 inv_1490 VDD VDD VDD PMOS l=6.000000000000001e-08 w=4.0000000000000003e-07
MN1492 inv_1490 VDD 0 0 NMOS l=6.000000000000001e-08 w=2.0000000000000002e-07
MN1494 0 inv_1490 xor_1493 0 NMOS l=6.000000000000001e-08 w=2.0000000000000002e-07
MP1495 0 VDD xor_1493 VDD PMOS l=6.000000000000001e-08 w=4.0000000000000003e-07
MN1496 inv_1487 VDD xor_1493 0 NMOS l=6.000000000000001e-08 w=2.0000000000000002e-07
MP1497 inv_1487 inv_1490 xor_1493 VDD PMOS l=6.000000000000001e-08 w=4.0000000000000003e-07
MP1499 inv_1498 xor_1493 VDD VDD PMOS l=6.000000000000001e-08 w=4.0000000000000003e-07
MN1500 inv_1498 xor_1493 0 0 NMOS l=6.000000000000001e-08 w=2.0000000000000002e-07
MP1502 inv_1501 inv_1484 VDD VDD PMOS l=6.000000000000001e-08 w=4.0000000000000003e-07
MN1503 inv_1501 inv_1484 0 0 NMOS l=6.000000000000001e-08 w=2.0000000000000002e-07
MN1505 xor_1493 inv_1501 xor_1504 0 NMOS l=6.000000000000001e-08 w=2.0000000000000002e-07
MP1506 xor_1493 inv_1484 xor_1504 VDD PMOS l=6.000000000000001e-08 w=4.0000000000000003e-07
MN1507 inv_1498 inv_1484 xor_1504 0 NMOS l=6.000000000000001e-08 w=2.0000000000000002e-07
MP1508 inv_1498 inv_1501 xor_1504 VDD PMOS l=6.000000000000001e-08 w=4.0000000000000003e-07
MN1510 inv_1484 xor_1493 cout_1509 0 NMOS l=6.000000000000001e-08 w=2.0000000000000002e-07
MP1511 inv_1484 inv_1498 cout_1509 VDD PMOS l=6.000000000000001e-08 w=4.0000000000000003e-07
MN1512 0 inv_1498 cout_1509 0 NMOS l=6.000000000000001e-08 w=2.0000000000000002e-07
MP1513 0 xor_1493 cout_1509 VDD PMOS l=6.000000000000001e-08 w=4.0000000000000003e-07
MP1515 inv_1514 cout_1509 VDD VDD PMOS l=6.000000000000001e-08 w=4.0000000000000003e-07
MN1516 inv_1514 cout_1509 0 0 NMOS l=6.000000000000001e-08 w=2.0000000000000002e-07
MP1518 inv_1517 inv_1514 VDD VDD PMOS l=6.000000000000001e-08 w=4.0000000000000003e-07
MN1519 inv_1517 inv_1514 0 0 NMOS l=6.000000000000001e-08 w=2.0000000000000002e-07
MP1521 inv_1520 xor_1171 VDD VDD PMOS l=6.000000000000001e-08 w=4.0000000000000003e-07
MN1522 inv_1520 xor_1171 0 0 NMOS l=6.000000000000001e-08 w=2.0000000000000002e-07
MN1524 xor_676 inv_1520 mux_1523 0 NMOS l=6.000000000000001e-08 w=2.0000000000000002e-07
MP1525 xor_676 xor_1171 mux_1523 VDD PMOS l=6.000000000000001e-08 w=4.0000000000000003e-07
MN1526 0 xor_1171 mux_1523 0 NMOS l=6.000000000000001e-08 w=2.0000000000000002e-07
MP1527 0 inv_1520 mux_1523 VDD PMOS l=6.000000000000001e-08 w=4.0000000000000003e-07
MN1529 xor_709 inv_1520 mux_1528 0 NMOS l=6.000000000000001e-08 w=2.0000000000000002e-07
MP1530 xor_709 xor_1171 mux_1528 VDD PMOS l=6.000000000000001e-08 w=4.0000000000000003e-07
MN1531 xor_676 xor_1171 mux_1528 0 NMOS l=6.000000000000001e-08 w=2.0000000000000002e-07
MP1532 xor_676 inv_1520 mux_1528 VDD PMOS l=6.000000000000001e-08 w=4.0000000000000003e-07
MN1534 xor_742 inv_1520 mux_1533 0 NMOS l=6.000000000000001e-08 w=2.0000000000000002e-07
MP1535 xor_742 xor_1171 mux_1533 VDD PMOS l=6.000000000000001e-08 w=4.0000000000000003e-07
MN1536 xor_709 xor_1171 mux_1533 0 NMOS l=6.000000000000001e-08 w=2.0000000000000002e-07
MP1537 xor_709 inv_1520 mux_1533 VDD PMOS l=6.000000000000001e-08 w=4.0000000000000003e-07
MN1539 xor_775 inv_1520 mux_1538 0 NMOS l=6.000000000000001e-08 w=2.0000000000000002e-07
MP1540 xor_775 xor_1171 mux_1538 VDD PMOS l=6.000000000000001e-08 w=4.0000000000000003e-07
MN1541 xor_742 xor_1171 mux_1538 0 NMOS l=6.000000000000001e-08 w=2.0000000000000002e-07
MP1542 xor_742 inv_1520 mux_1538 VDD PMOS l=6.000000000000001e-08 w=4.0000000000000003e-07
MN1544 xor_808 inv_1520 mux_1543 0 NMOS l=6.000000000000001e-08 w=2.0000000000000002e-07
MP1545 xor_808 xor_1171 mux_1543 VDD PMOS l=6.000000000000001e-08 w=4.0000000000000003e-07
MN1546 xor_775 xor_1171 mux_1543 0 NMOS l=6.000000000000001e-08 w=2.0000000000000002e-07
MP1547 xor_775 inv_1520 mux_1543 VDD PMOS l=6.000000000000001e-08 w=4.0000000000000003e-07
MN1549 xor_841 inv_1520 mux_1548 0 NMOS l=6.000000000000001e-08 w=2.0000000000000002e-07
MP1550 xor_841 xor_1171 mux_1548 VDD PMOS l=6.000000000000001e-08 w=4.0000000000000003e-07
MN1551 xor_808 xor_1171 mux_1548 0 NMOS l=6.000000000000001e-08 w=2.0000000000000002e-07
MP1552 xor_808 inv_1520 mux_1548 VDD PMOS l=6.000000000000001e-08 w=4.0000000000000003e-07
MN1554 xor_874 inv_1520 mux_1553 0 NMOS l=6.000000000000001e-08 w=2.0000000000000002e-07
MP1555 xor_874 xor_1171 mux_1553 VDD PMOS l=6.000000000000001e-08 w=4.0000000000000003e-07
MN1556 xor_841 xor_1171 mux_1553 0 NMOS l=6.000000000000001e-08 w=2.0000000000000002e-07
MP1557 xor_841 inv_1520 mux_1553 VDD PMOS l=6.000000000000001e-08 w=4.0000000000000003e-07
MN1559 xor_907 inv_1520 mux_1558 0 NMOS l=6.000000000000001e-08 w=2.0000000000000002e-07
MP1560 xor_907 xor_1171 mux_1558 VDD PMOS l=6.000000000000001e-08 w=4.0000000000000003e-07
MN1561 xor_874 xor_1171 mux_1558 0 NMOS l=6.000000000000001e-08 w=2.0000000000000002e-07
MP1562 xor_874 inv_1520 mux_1558 VDD PMOS l=6.000000000000001e-08 w=4.0000000000000003e-07
MN1564 0 inv_1520 mux_1563 0 NMOS l=6.000000000000001e-08 w=2.0000000000000002e-07
MP1565 0 xor_1171 mux_1563 VDD PMOS l=6.000000000000001e-08 w=4.0000000000000003e-07
MN1566 xor_907 xor_1171 mux_1563 0 NMOS l=6.000000000000001e-08 w=2.0000000000000002e-07
MP1567 xor_907 inv_1520 mux_1563 VDD PMOS l=6.000000000000001e-08 w=4.0000000000000003e-07
MN1569 0 inv_1520 mux_1568 0 NMOS l=6.000000000000001e-08 w=2.0000000000000002e-07
MP1570 0 xor_1171 mux_1568 VDD PMOS l=6.000000000000001e-08 w=4.0000000000000003e-07
MN1571 0 xor_1171 mux_1568 0 NMOS l=6.000000000000001e-08 w=2.0000000000000002e-07
MP1572 0 inv_1520 mux_1568 VDD PMOS l=6.000000000000001e-08 w=4.0000000000000003e-07
MN1574 0 inv_1520 mux_1573 0 NMOS l=6.000000000000001e-08 w=2.0000000000000002e-07
MP1575 0 xor_1171 mux_1573 VDD PMOS l=6.000000000000001e-08 w=4.0000000000000003e-07
MN1576 0 xor_1171 mux_1573 0 NMOS l=6.000000000000001e-08 w=2.0000000000000002e-07
MP1577 0 inv_1520 mux_1573 VDD PMOS l=6.000000000000001e-08 w=4.0000000000000003e-07
MN1579 0 inv_1520 mux_1578 0 NMOS l=6.000000000000001e-08 w=2.0000000000000002e-07
MP1580 0 xor_1171 mux_1578 VDD PMOS l=6.000000000000001e-08 w=4.0000000000000003e-07
MN1581 0 xor_1171 mux_1578 0 NMOS l=6.000000000000001e-08 w=2.0000000000000002e-07
MP1582 0 inv_1520 mux_1578 VDD PMOS l=6.000000000000001e-08 w=4.0000000000000003e-07
MN1584 0 inv_1520 mux_1583 0 NMOS l=6.000000000000001e-08 w=2.0000000000000002e-07
MP1585 0 xor_1171 mux_1583 VDD PMOS l=6.000000000000001e-08 w=4.0000000000000003e-07
MN1586 0 xor_1171 mux_1583 0 NMOS l=6.000000000000001e-08 w=2.0000000000000002e-07
MP1587 0 inv_1520 mux_1583 VDD PMOS l=6.000000000000001e-08 w=4.0000000000000003e-07
MN1589 0 inv_1520 mux_1588 0 NMOS l=6.000000000000001e-08 w=2.0000000000000002e-07
MP1590 0 xor_1171 mux_1588 VDD PMOS l=6.000000000000001e-08 w=4.0000000000000003e-07
MN1591 0 xor_1171 mux_1588 0 NMOS l=6.000000000000001e-08 w=2.0000000000000002e-07
MP1592 0 inv_1520 mux_1588 VDD PMOS l=6.000000000000001e-08 w=4.0000000000000003e-07
MN1594 0 inv_1520 mux_1593 0 NMOS l=6.000000000000001e-08 w=2.0000000000000002e-07
MP1595 0 xor_1171 mux_1593 VDD PMOS l=6.000000000000001e-08 w=4.0000000000000003e-07
MN1596 0 xor_1171 mux_1593 0 NMOS l=6.000000000000001e-08 w=2.0000000000000002e-07
MP1597 0 inv_1520 mux_1593 VDD PMOS l=6.000000000000001e-08 w=4.0000000000000003e-07
MN1599 0 inv_1520 mux_1598 0 NMOS l=6.000000000000001e-08 w=2.0000000000000002e-07
MP1600 0 xor_1171 mux_1598 VDD PMOS l=6.000000000000001e-08 w=4.0000000000000003e-07
MN1601 0 xor_1171 mux_1598 0 NMOS l=6.000000000000001e-08 w=2.0000000000000002e-07
MP1602 0 inv_1520 mux_1598 VDD PMOS l=6.000000000000001e-08 w=4.0000000000000003e-07
MN1604 0 inv_1520 mux_1603 0 NMOS l=6.000000000000001e-08 w=2.0000000000000002e-07
MP1605 0 xor_1171 mux_1603 VDD PMOS l=6.000000000000001e-08 w=4.0000000000000003e-07
MN1606 0 xor_1171 mux_1603 0 NMOS l=6.000000000000001e-08 w=2.0000000000000002e-07
MP1607 0 inv_1520 mux_1603 VDD PMOS l=6.000000000000001e-08 w=4.0000000000000003e-07
MN1609 0 inv_1520 mux_1608 0 NMOS l=6.000000000000001e-08 w=2.0000000000000002e-07
MP1610 0 xor_1171 mux_1608 VDD PMOS l=6.000000000000001e-08 w=4.0000000000000003e-07
MN1611 0 xor_1171 mux_1608 0 NMOS l=6.000000000000001e-08 w=2.0000000000000002e-07
MP1612 0 inv_1520 mux_1608 VDD PMOS l=6.000000000000001e-08 w=4.0000000000000003e-07
MN1614 0 inv_1520 mux_1613 0 NMOS l=6.000000000000001e-08 w=2.0000000000000002e-07
MP1615 0 xor_1171 mux_1613 VDD PMOS l=6.000000000000001e-08 w=4.0000000000000003e-07
MN1616 0 xor_1171 mux_1613 0 NMOS l=6.000000000000001e-08 w=2.0000000000000002e-07
MP1617 0 inv_1520 mux_1613 VDD PMOS l=6.000000000000001e-08 w=4.0000000000000003e-07
MN1619 0 inv_1520 mux_1618 0 NMOS l=6.000000000000001e-08 w=2.0000000000000002e-07
MP1620 0 xor_1171 mux_1618 VDD PMOS l=6.000000000000001e-08 w=4.0000000000000003e-07
MN1621 0 xor_1171 mux_1618 0 NMOS l=6.000000000000001e-08 w=2.0000000000000002e-07
MP1622 0 inv_1520 mux_1618 VDD PMOS l=6.000000000000001e-08 w=4.0000000000000003e-07
MN1624 0 inv_1520 mux_1623 0 NMOS l=6.000000000000001e-08 w=2.0000000000000002e-07
MP1625 0 xor_1171 mux_1623 VDD PMOS l=6.000000000000001e-08 w=4.0000000000000003e-07
MN1626 0 xor_1171 mux_1623 0 NMOS l=6.000000000000001e-08 w=2.0000000000000002e-07
MP1627 0 inv_1520 mux_1623 VDD PMOS l=6.000000000000001e-08 w=4.0000000000000003e-07
MP1629 inv_1628 xor_1204 VDD VDD PMOS l=6.000000000000001e-08 w=4.0000000000000003e-07
MN1630 inv_1628 xor_1204 0 0 NMOS l=6.000000000000001e-08 w=2.0000000000000002e-07
MN1632 mux_1523 inv_1628 mux_1631 0 NMOS l=6.000000000000001e-08 w=2.0000000000000002e-07
MP1633 mux_1523 xor_1204 mux_1631 VDD PMOS l=6.000000000000001e-08 w=4.0000000000000003e-07
MN1634 0 xor_1204 mux_1631 0 NMOS l=6.000000000000001e-08 w=2.0000000000000002e-07
MP1635 0 inv_1628 mux_1631 VDD PMOS l=6.000000000000001e-08 w=4.0000000000000003e-07
MN1637 mux_1528 inv_1628 mux_1636 0 NMOS l=6.000000000000001e-08 w=2.0000000000000002e-07
MP1638 mux_1528 xor_1204 mux_1636 VDD PMOS l=6.000000000000001e-08 w=4.0000000000000003e-07
MN1639 0 xor_1204 mux_1636 0 NMOS l=6.000000000000001e-08 w=2.0000000000000002e-07
MP1640 0 inv_1628 mux_1636 VDD PMOS l=6.000000000000001e-08 w=4.0000000000000003e-07
MN1642 mux_1533 inv_1628 mux_1641 0 NMOS l=6.000000000000001e-08 w=2.0000000000000002e-07
MP1643 mux_1533 xor_1204 mux_1641 VDD PMOS l=6.000000000000001e-08 w=4.0000000000000003e-07
MN1644 mux_1523 xor_1204 mux_1641 0 NMOS l=6.000000000000001e-08 w=2.0000000000000002e-07
MP1645 mux_1523 inv_1628 mux_1641 VDD PMOS l=6.000000000000001e-08 w=4.0000000000000003e-07
MN1647 mux_1538 inv_1628 mux_1646 0 NMOS l=6.000000000000001e-08 w=2.0000000000000002e-07
MP1648 mux_1538 xor_1204 mux_1646 VDD PMOS l=6.000000000000001e-08 w=4.0000000000000003e-07
MN1649 mux_1528 xor_1204 mux_1646 0 NMOS l=6.000000000000001e-08 w=2.0000000000000002e-07
MP1650 mux_1528 inv_1628 mux_1646 VDD PMOS l=6.000000000000001e-08 w=4.0000000000000003e-07
MN1652 mux_1543 inv_1628 mux_1651 0 NMOS l=6.000000000000001e-08 w=2.0000000000000002e-07
MP1653 mux_1543 xor_1204 mux_1651 VDD PMOS l=6.000000000000001e-08 w=4.0000000000000003e-07
MN1654 mux_1533 xor_1204 mux_1651 0 NMOS l=6.000000000000001e-08 w=2.0000000000000002e-07
MP1655 mux_1533 inv_1628 mux_1651 VDD PMOS l=6.000000000000001e-08 w=4.0000000000000003e-07
MN1657 mux_1548 inv_1628 mux_1656 0 NMOS l=6.000000000000001e-08 w=2.0000000000000002e-07
MP1658 mux_1548 xor_1204 mux_1656 VDD PMOS l=6.000000000000001e-08 w=4.0000000000000003e-07
MN1659 mux_1538 xor_1204 mux_1656 0 NMOS l=6.000000000000001e-08 w=2.0000000000000002e-07
MP1660 mux_1538 inv_1628 mux_1656 VDD PMOS l=6.000000000000001e-08 w=4.0000000000000003e-07
MN1662 mux_1553 inv_1628 mux_1661 0 NMOS l=6.000000000000001e-08 w=2.0000000000000002e-07
MP1663 mux_1553 xor_1204 mux_1661 VDD PMOS l=6.000000000000001e-08 w=4.0000000000000003e-07
MN1664 mux_1543 xor_1204 mux_1661 0 NMOS l=6.000000000000001e-08 w=2.0000000000000002e-07
MP1665 mux_1543 inv_1628 mux_1661 VDD PMOS l=6.000000000000001e-08 w=4.0000000000000003e-07
MN1667 mux_1558 inv_1628 mux_1666 0 NMOS l=6.000000000000001e-08 w=2.0000000000000002e-07
MP1668 mux_1558 xor_1204 mux_1666 VDD PMOS l=6.000000000000001e-08 w=4.0000000000000003e-07
MN1669 mux_1548 xor_1204 mux_1666 0 NMOS l=6.000000000000001e-08 w=2.0000000000000002e-07
MP1670 mux_1548 inv_1628 mux_1666 VDD PMOS l=6.000000000000001e-08 w=4.0000000000000003e-07
MN1672 mux_1563 inv_1628 mux_1671 0 NMOS l=6.000000000000001e-08 w=2.0000000000000002e-07
MP1673 mux_1563 xor_1204 mux_1671 VDD PMOS l=6.000000000000001e-08 w=4.0000000000000003e-07
MN1674 mux_1553 xor_1204 mux_1671 0 NMOS l=6.000000000000001e-08 w=2.0000000000000002e-07
MP1675 mux_1553 inv_1628 mux_1671 VDD PMOS l=6.000000000000001e-08 w=4.0000000000000003e-07
MN1677 mux_1568 inv_1628 mux_1676 0 NMOS l=6.000000000000001e-08 w=2.0000000000000002e-07
MP1678 mux_1568 xor_1204 mux_1676 VDD PMOS l=6.000000000000001e-08 w=4.0000000000000003e-07
MN1679 mux_1558 xor_1204 mux_1676 0 NMOS l=6.000000000000001e-08 w=2.0000000000000002e-07
MP1680 mux_1558 inv_1628 mux_1676 VDD PMOS l=6.000000000000001e-08 w=4.0000000000000003e-07
MN1682 mux_1573 inv_1628 mux_1681 0 NMOS l=6.000000000000001e-08 w=2.0000000000000002e-07
MP1683 mux_1573 xor_1204 mux_1681 VDD PMOS l=6.000000000000001e-08 w=4.0000000000000003e-07
MN1684 mux_1563 xor_1204 mux_1681 0 NMOS l=6.000000000000001e-08 w=2.0000000000000002e-07
MP1685 mux_1563 inv_1628 mux_1681 VDD PMOS l=6.000000000000001e-08 w=4.0000000000000003e-07
MN1687 mux_1578 inv_1628 mux_1686 0 NMOS l=6.000000000000001e-08 w=2.0000000000000002e-07
MP1688 mux_1578 xor_1204 mux_1686 VDD PMOS l=6.000000000000001e-08 w=4.0000000000000003e-07
MN1689 mux_1568 xor_1204 mux_1686 0 NMOS l=6.000000000000001e-08 w=2.0000000000000002e-07
MP1690 mux_1568 inv_1628 mux_1686 VDD PMOS l=6.000000000000001e-08 w=4.0000000000000003e-07
MN1692 mux_1583 inv_1628 mux_1691 0 NMOS l=6.000000000000001e-08 w=2.0000000000000002e-07
MP1693 mux_1583 xor_1204 mux_1691 VDD PMOS l=6.000000000000001e-08 w=4.0000000000000003e-07
MN1694 mux_1573 xor_1204 mux_1691 0 NMOS l=6.000000000000001e-08 w=2.0000000000000002e-07
MP1695 mux_1573 inv_1628 mux_1691 VDD PMOS l=6.000000000000001e-08 w=4.0000000000000003e-07
MN1697 mux_1588 inv_1628 mux_1696 0 NMOS l=6.000000000000001e-08 w=2.0000000000000002e-07
MP1698 mux_1588 xor_1204 mux_1696 VDD PMOS l=6.000000000000001e-08 w=4.0000000000000003e-07
MN1699 mux_1578 xor_1204 mux_1696 0 NMOS l=6.000000000000001e-08 w=2.0000000000000002e-07
MP1700 mux_1578 inv_1628 mux_1696 VDD PMOS l=6.000000000000001e-08 w=4.0000000000000003e-07
MN1702 mux_1593 inv_1628 mux_1701 0 NMOS l=6.000000000000001e-08 w=2.0000000000000002e-07
MP1703 mux_1593 xor_1204 mux_1701 VDD PMOS l=6.000000000000001e-08 w=4.0000000000000003e-07
MN1704 mux_1583 xor_1204 mux_1701 0 NMOS l=6.000000000000001e-08 w=2.0000000000000002e-07
MP1705 mux_1583 inv_1628 mux_1701 VDD PMOS l=6.000000000000001e-08 w=4.0000000000000003e-07
MN1707 mux_1598 inv_1628 mux_1706 0 NMOS l=6.000000000000001e-08 w=2.0000000000000002e-07
MP1708 mux_1598 xor_1204 mux_1706 VDD PMOS l=6.000000000000001e-08 w=4.0000000000000003e-07
MN1709 mux_1588 xor_1204 mux_1706 0 NMOS l=6.000000000000001e-08 w=2.0000000000000002e-07
MP1710 mux_1588 inv_1628 mux_1706 VDD PMOS l=6.000000000000001e-08 w=4.0000000000000003e-07
MN1712 mux_1603 inv_1628 mux_1711 0 NMOS l=6.000000000000001e-08 w=2.0000000000000002e-07
MP1713 mux_1603 xor_1204 mux_1711 VDD PMOS l=6.000000000000001e-08 w=4.0000000000000003e-07
MN1714 mux_1593 xor_1204 mux_1711 0 NMOS l=6.000000000000001e-08 w=2.0000000000000002e-07
MP1715 mux_1593 inv_1628 mux_1711 VDD PMOS l=6.000000000000001e-08 w=4.0000000000000003e-07
MN1717 mux_1608 inv_1628 mux_1716 0 NMOS l=6.000000000000001e-08 w=2.0000000000000002e-07
MP1718 mux_1608 xor_1204 mux_1716 VDD PMOS l=6.000000000000001e-08 w=4.0000000000000003e-07
MN1719 mux_1598 xor_1204 mux_1716 0 NMOS l=6.000000000000001e-08 w=2.0000000000000002e-07
MP1720 mux_1598 inv_1628 mux_1716 VDD PMOS l=6.000000000000001e-08 w=4.0000000000000003e-07
MN1722 mux_1613 inv_1628 mux_1721 0 NMOS l=6.000000000000001e-08 w=2.0000000000000002e-07
MP1723 mux_1613 xor_1204 mux_1721 VDD PMOS l=6.000000000000001e-08 w=4.0000000000000003e-07
MN1724 mux_1603 xor_1204 mux_1721 0 NMOS l=6.000000000000001e-08 w=2.0000000000000002e-07
MP1725 mux_1603 inv_1628 mux_1721 VDD PMOS l=6.000000000000001e-08 w=4.0000000000000003e-07
MN1727 mux_1618 inv_1628 mux_1726 0 NMOS l=6.000000000000001e-08 w=2.0000000000000002e-07
MP1728 mux_1618 xor_1204 mux_1726 VDD PMOS l=6.000000000000001e-08 w=4.0000000000000003e-07
MN1729 mux_1608 xor_1204 mux_1726 0 NMOS l=6.000000000000001e-08 w=2.0000000000000002e-07
MP1730 mux_1608 inv_1628 mux_1726 VDD PMOS l=6.000000000000001e-08 w=4.0000000000000003e-07
MN1732 mux_1623 inv_1628 mux_1731 0 NMOS l=6.000000000000001e-08 w=2.0000000000000002e-07
MP1733 mux_1623 xor_1204 mux_1731 VDD PMOS l=6.000000000000001e-08 w=4.0000000000000003e-07
MN1734 mux_1613 xor_1204 mux_1731 0 NMOS l=6.000000000000001e-08 w=2.0000000000000002e-07
MP1735 mux_1613 inv_1628 mux_1731 VDD PMOS l=6.000000000000001e-08 w=4.0000000000000003e-07
MP1737 inv_1736 xor_1237 VDD VDD PMOS l=6.000000000000001e-08 w=4.0000000000000003e-07
MN1738 inv_1736 xor_1237 0 0 NMOS l=6.000000000000001e-08 w=2.0000000000000002e-07
MN1740 mux_1631 inv_1736 mux_1739 0 NMOS l=6.000000000000001e-08 w=2.0000000000000002e-07
MP1741 mux_1631 xor_1237 mux_1739 VDD PMOS l=6.000000000000001e-08 w=4.0000000000000003e-07
MN1742 0 xor_1237 mux_1739 0 NMOS l=6.000000000000001e-08 w=2.0000000000000002e-07
MP1743 0 inv_1736 mux_1739 VDD PMOS l=6.000000000000001e-08 w=4.0000000000000003e-07
MN1745 mux_1636 inv_1736 mux_1744 0 NMOS l=6.000000000000001e-08 w=2.0000000000000002e-07
MP1746 mux_1636 xor_1237 mux_1744 VDD PMOS l=6.000000000000001e-08 w=4.0000000000000003e-07
MN1747 0 xor_1237 mux_1744 0 NMOS l=6.000000000000001e-08 w=2.0000000000000002e-07
MP1748 0 inv_1736 mux_1744 VDD PMOS l=6.000000000000001e-08 w=4.0000000000000003e-07
MN1750 mux_1641 inv_1736 mux_1749 0 NMOS l=6.000000000000001e-08 w=2.0000000000000002e-07
MP1751 mux_1641 xor_1237 mux_1749 VDD PMOS l=6.000000000000001e-08 w=4.0000000000000003e-07
MN1752 0 xor_1237 mux_1749 0 NMOS l=6.000000000000001e-08 w=2.0000000000000002e-07
MP1753 0 inv_1736 mux_1749 VDD PMOS l=6.000000000000001e-08 w=4.0000000000000003e-07
MN1755 mux_1646 inv_1736 mux_1754 0 NMOS l=6.000000000000001e-08 w=2.0000000000000002e-07
MP1756 mux_1646 xor_1237 mux_1754 VDD PMOS l=6.000000000000001e-08 w=4.0000000000000003e-07
MN1757 0 xor_1237 mux_1754 0 NMOS l=6.000000000000001e-08 w=2.0000000000000002e-07
MP1758 0 inv_1736 mux_1754 VDD PMOS l=6.000000000000001e-08 w=4.0000000000000003e-07
MN1760 mux_1651 inv_1736 mux_1759 0 NMOS l=6.000000000000001e-08 w=2.0000000000000002e-07
MP1761 mux_1651 xor_1237 mux_1759 VDD PMOS l=6.000000000000001e-08 w=4.0000000000000003e-07
MN1762 mux_1631 xor_1237 mux_1759 0 NMOS l=6.000000000000001e-08 w=2.0000000000000002e-07
MP1763 mux_1631 inv_1736 mux_1759 VDD PMOS l=6.000000000000001e-08 w=4.0000000000000003e-07
MN1765 mux_1656 inv_1736 mux_1764 0 NMOS l=6.000000000000001e-08 w=2.0000000000000002e-07
MP1766 mux_1656 xor_1237 mux_1764 VDD PMOS l=6.000000000000001e-08 w=4.0000000000000003e-07
MN1767 mux_1636 xor_1237 mux_1764 0 NMOS l=6.000000000000001e-08 w=2.0000000000000002e-07
MP1768 mux_1636 inv_1736 mux_1764 VDD PMOS l=6.000000000000001e-08 w=4.0000000000000003e-07
MN1770 mux_1661 inv_1736 mux_1769 0 NMOS l=6.000000000000001e-08 w=2.0000000000000002e-07
MP1771 mux_1661 xor_1237 mux_1769 VDD PMOS l=6.000000000000001e-08 w=4.0000000000000003e-07
MN1772 mux_1641 xor_1237 mux_1769 0 NMOS l=6.000000000000001e-08 w=2.0000000000000002e-07
MP1773 mux_1641 inv_1736 mux_1769 VDD PMOS l=6.000000000000001e-08 w=4.0000000000000003e-07
MN1775 mux_1666 inv_1736 mux_1774 0 NMOS l=6.000000000000001e-08 w=2.0000000000000002e-07
MP1776 mux_1666 xor_1237 mux_1774 VDD PMOS l=6.000000000000001e-08 w=4.0000000000000003e-07
MN1777 mux_1646 xor_1237 mux_1774 0 NMOS l=6.000000000000001e-08 w=2.0000000000000002e-07
MP1778 mux_1646 inv_1736 mux_1774 VDD PMOS l=6.000000000000001e-08 w=4.0000000000000003e-07
MN1780 mux_1671 inv_1736 mux_1779 0 NMOS l=6.000000000000001e-08 w=2.0000000000000002e-07
MP1781 mux_1671 xor_1237 mux_1779 VDD PMOS l=6.000000000000001e-08 w=4.0000000000000003e-07
MN1782 mux_1651 xor_1237 mux_1779 0 NMOS l=6.000000000000001e-08 w=2.0000000000000002e-07
MP1783 mux_1651 inv_1736 mux_1779 VDD PMOS l=6.000000000000001e-08 w=4.0000000000000003e-07
MN1785 mux_1676 inv_1736 mux_1784 0 NMOS l=6.000000000000001e-08 w=2.0000000000000002e-07
MP1786 mux_1676 xor_1237 mux_1784 VDD PMOS l=6.000000000000001e-08 w=4.0000000000000003e-07
MN1787 mux_1656 xor_1237 mux_1784 0 NMOS l=6.000000000000001e-08 w=2.0000000000000002e-07
MP1788 mux_1656 inv_1736 mux_1784 VDD PMOS l=6.000000000000001e-08 w=4.0000000000000003e-07
MN1790 mux_1681 inv_1736 mux_1789 0 NMOS l=6.000000000000001e-08 w=2.0000000000000002e-07
MP1791 mux_1681 xor_1237 mux_1789 VDD PMOS l=6.000000000000001e-08 w=4.0000000000000003e-07
MN1792 mux_1661 xor_1237 mux_1789 0 NMOS l=6.000000000000001e-08 w=2.0000000000000002e-07
MP1793 mux_1661 inv_1736 mux_1789 VDD PMOS l=6.000000000000001e-08 w=4.0000000000000003e-07
MN1795 mux_1686 inv_1736 mux_1794 0 NMOS l=6.000000000000001e-08 w=2.0000000000000002e-07
MP1796 mux_1686 xor_1237 mux_1794 VDD PMOS l=6.000000000000001e-08 w=4.0000000000000003e-07
MN1797 mux_1666 xor_1237 mux_1794 0 NMOS l=6.000000000000001e-08 w=2.0000000000000002e-07
MP1798 mux_1666 inv_1736 mux_1794 VDD PMOS l=6.000000000000001e-08 w=4.0000000000000003e-07
MN1800 mux_1691 inv_1736 mux_1799 0 NMOS l=6.000000000000001e-08 w=2.0000000000000002e-07
MP1801 mux_1691 xor_1237 mux_1799 VDD PMOS l=6.000000000000001e-08 w=4.0000000000000003e-07
MN1802 mux_1671 xor_1237 mux_1799 0 NMOS l=6.000000000000001e-08 w=2.0000000000000002e-07
MP1803 mux_1671 inv_1736 mux_1799 VDD PMOS l=6.000000000000001e-08 w=4.0000000000000003e-07
MN1805 mux_1696 inv_1736 mux_1804 0 NMOS l=6.000000000000001e-08 w=2.0000000000000002e-07
MP1806 mux_1696 xor_1237 mux_1804 VDD PMOS l=6.000000000000001e-08 w=4.0000000000000003e-07
MN1807 mux_1676 xor_1237 mux_1804 0 NMOS l=6.000000000000001e-08 w=2.0000000000000002e-07
MP1808 mux_1676 inv_1736 mux_1804 VDD PMOS l=6.000000000000001e-08 w=4.0000000000000003e-07
MN1810 mux_1701 inv_1736 mux_1809 0 NMOS l=6.000000000000001e-08 w=2.0000000000000002e-07
MP1811 mux_1701 xor_1237 mux_1809 VDD PMOS l=6.000000000000001e-08 w=4.0000000000000003e-07
MN1812 mux_1681 xor_1237 mux_1809 0 NMOS l=6.000000000000001e-08 w=2.0000000000000002e-07
MP1813 mux_1681 inv_1736 mux_1809 VDD PMOS l=6.000000000000001e-08 w=4.0000000000000003e-07
MN1815 mux_1706 inv_1736 mux_1814 0 NMOS l=6.000000000000001e-08 w=2.0000000000000002e-07
MP1816 mux_1706 xor_1237 mux_1814 VDD PMOS l=6.000000000000001e-08 w=4.0000000000000003e-07
MN1817 mux_1686 xor_1237 mux_1814 0 NMOS l=6.000000000000001e-08 w=2.0000000000000002e-07
MP1818 mux_1686 inv_1736 mux_1814 VDD PMOS l=6.000000000000001e-08 w=4.0000000000000003e-07
MN1820 mux_1711 inv_1736 mux_1819 0 NMOS l=6.000000000000001e-08 w=2.0000000000000002e-07
MP1821 mux_1711 xor_1237 mux_1819 VDD PMOS l=6.000000000000001e-08 w=4.0000000000000003e-07
MN1822 mux_1691 xor_1237 mux_1819 0 NMOS l=6.000000000000001e-08 w=2.0000000000000002e-07
MP1823 mux_1691 inv_1736 mux_1819 VDD PMOS l=6.000000000000001e-08 w=4.0000000000000003e-07
MN1825 mux_1716 inv_1736 mux_1824 0 NMOS l=6.000000000000001e-08 w=2.0000000000000002e-07
MP1826 mux_1716 xor_1237 mux_1824 VDD PMOS l=6.000000000000001e-08 w=4.0000000000000003e-07
MN1827 mux_1696 xor_1237 mux_1824 0 NMOS l=6.000000000000001e-08 w=2.0000000000000002e-07
MP1828 mux_1696 inv_1736 mux_1824 VDD PMOS l=6.000000000000001e-08 w=4.0000000000000003e-07
MN1830 mux_1721 inv_1736 mux_1829 0 NMOS l=6.000000000000001e-08 w=2.0000000000000002e-07
MP1831 mux_1721 xor_1237 mux_1829 VDD PMOS l=6.000000000000001e-08 w=4.0000000000000003e-07
MN1832 mux_1701 xor_1237 mux_1829 0 NMOS l=6.000000000000001e-08 w=2.0000000000000002e-07
MP1833 mux_1701 inv_1736 mux_1829 VDD PMOS l=6.000000000000001e-08 w=4.0000000000000003e-07
MN1835 mux_1726 inv_1736 mux_1834 0 NMOS l=6.000000000000001e-08 w=2.0000000000000002e-07
MP1836 mux_1726 xor_1237 mux_1834 VDD PMOS l=6.000000000000001e-08 w=4.0000000000000003e-07
MN1837 mux_1706 xor_1237 mux_1834 0 NMOS l=6.000000000000001e-08 w=2.0000000000000002e-07
MP1838 mux_1706 inv_1736 mux_1834 VDD PMOS l=6.000000000000001e-08 w=4.0000000000000003e-07
MN1840 mux_1731 inv_1736 mux_1839 0 NMOS l=6.000000000000001e-08 w=2.0000000000000002e-07
MP1841 mux_1731 xor_1237 mux_1839 VDD PMOS l=6.000000000000001e-08 w=4.0000000000000003e-07
MN1842 mux_1711 xor_1237 mux_1839 0 NMOS l=6.000000000000001e-08 w=2.0000000000000002e-07
MP1843 mux_1711 inv_1736 mux_1839 VDD PMOS l=6.000000000000001e-08 w=4.0000000000000003e-07
MP1845 inv_1844 xor_1270 VDD VDD PMOS l=6.000000000000001e-08 w=4.0000000000000003e-07
MN1846 inv_1844 xor_1270 0 0 NMOS l=6.000000000000001e-08 w=2.0000000000000002e-07
MN1848 mux_1739 inv_1844 mux_1847 0 NMOS l=6.000000000000001e-08 w=2.0000000000000002e-07
MP1849 mux_1739 xor_1270 mux_1847 VDD PMOS l=6.000000000000001e-08 w=4.0000000000000003e-07
MN1850 0 xor_1270 mux_1847 0 NMOS l=6.000000000000001e-08 w=2.0000000000000002e-07
MP1851 0 inv_1844 mux_1847 VDD PMOS l=6.000000000000001e-08 w=4.0000000000000003e-07
MN1853 mux_1744 inv_1844 mux_1852 0 NMOS l=6.000000000000001e-08 w=2.0000000000000002e-07
MP1854 mux_1744 xor_1270 mux_1852 VDD PMOS l=6.000000000000001e-08 w=4.0000000000000003e-07
MN1855 0 xor_1270 mux_1852 0 NMOS l=6.000000000000001e-08 w=2.0000000000000002e-07
MP1856 0 inv_1844 mux_1852 VDD PMOS l=6.000000000000001e-08 w=4.0000000000000003e-07
MN1858 mux_1749 inv_1844 mux_1857 0 NMOS l=6.000000000000001e-08 w=2.0000000000000002e-07
MP1859 mux_1749 xor_1270 mux_1857 VDD PMOS l=6.000000000000001e-08 w=4.0000000000000003e-07
MN1860 0 xor_1270 mux_1857 0 NMOS l=6.000000000000001e-08 w=2.0000000000000002e-07
MP1861 0 inv_1844 mux_1857 VDD PMOS l=6.000000000000001e-08 w=4.0000000000000003e-07
MN1863 mux_1754 inv_1844 mux_1862 0 NMOS l=6.000000000000001e-08 w=2.0000000000000002e-07
MP1864 mux_1754 xor_1270 mux_1862 VDD PMOS l=6.000000000000001e-08 w=4.0000000000000003e-07
MN1865 0 xor_1270 mux_1862 0 NMOS l=6.000000000000001e-08 w=2.0000000000000002e-07
MP1866 0 inv_1844 mux_1862 VDD PMOS l=6.000000000000001e-08 w=4.0000000000000003e-07
MN1868 mux_1759 inv_1844 mux_1867 0 NMOS l=6.000000000000001e-08 w=2.0000000000000002e-07
MP1869 mux_1759 xor_1270 mux_1867 VDD PMOS l=6.000000000000001e-08 w=4.0000000000000003e-07
MN1870 0 xor_1270 mux_1867 0 NMOS l=6.000000000000001e-08 w=2.0000000000000002e-07
MP1871 0 inv_1844 mux_1867 VDD PMOS l=6.000000000000001e-08 w=4.0000000000000003e-07
MN1873 mux_1764 inv_1844 mux_1872 0 NMOS l=6.000000000000001e-08 w=2.0000000000000002e-07
MP1874 mux_1764 xor_1270 mux_1872 VDD PMOS l=6.000000000000001e-08 w=4.0000000000000003e-07
MN1875 0 xor_1270 mux_1872 0 NMOS l=6.000000000000001e-08 w=2.0000000000000002e-07
MP1876 0 inv_1844 mux_1872 VDD PMOS l=6.000000000000001e-08 w=4.0000000000000003e-07
MN1878 mux_1769 inv_1844 mux_1877 0 NMOS l=6.000000000000001e-08 w=2.0000000000000002e-07
MP1879 mux_1769 xor_1270 mux_1877 VDD PMOS l=6.000000000000001e-08 w=4.0000000000000003e-07
MN1880 0 xor_1270 mux_1877 0 NMOS l=6.000000000000001e-08 w=2.0000000000000002e-07
MP1881 0 inv_1844 mux_1877 VDD PMOS l=6.000000000000001e-08 w=4.0000000000000003e-07
MN1883 mux_1774 inv_1844 mux_1882 0 NMOS l=6.000000000000001e-08 w=2.0000000000000002e-07
MP1884 mux_1774 xor_1270 mux_1882 VDD PMOS l=6.000000000000001e-08 w=4.0000000000000003e-07
MN1885 0 xor_1270 mux_1882 0 NMOS l=6.000000000000001e-08 w=2.0000000000000002e-07
MP1886 0 inv_1844 mux_1882 VDD PMOS l=6.000000000000001e-08 w=4.0000000000000003e-07
MN1888 mux_1779 inv_1844 mux_1887 0 NMOS l=6.000000000000001e-08 w=2.0000000000000002e-07
MP1889 mux_1779 xor_1270 mux_1887 VDD PMOS l=6.000000000000001e-08 w=4.0000000000000003e-07
MN1890 mux_1739 xor_1270 mux_1887 0 NMOS l=6.000000000000001e-08 w=2.0000000000000002e-07
MP1891 mux_1739 inv_1844 mux_1887 VDD PMOS l=6.000000000000001e-08 w=4.0000000000000003e-07
MN1893 mux_1784 inv_1844 mux_1892 0 NMOS l=6.000000000000001e-08 w=2.0000000000000002e-07
MP1894 mux_1784 xor_1270 mux_1892 VDD PMOS l=6.000000000000001e-08 w=4.0000000000000003e-07
MN1895 mux_1744 xor_1270 mux_1892 0 NMOS l=6.000000000000001e-08 w=2.0000000000000002e-07
MP1896 mux_1744 inv_1844 mux_1892 VDD PMOS l=6.000000000000001e-08 w=4.0000000000000003e-07
MN1898 mux_1789 inv_1844 mux_1897 0 NMOS l=6.000000000000001e-08 w=2.0000000000000002e-07
MP1899 mux_1789 xor_1270 mux_1897 VDD PMOS l=6.000000000000001e-08 w=4.0000000000000003e-07
MN1900 mux_1749 xor_1270 mux_1897 0 NMOS l=6.000000000000001e-08 w=2.0000000000000002e-07
MP1901 mux_1749 inv_1844 mux_1897 VDD PMOS l=6.000000000000001e-08 w=4.0000000000000003e-07
MN1903 mux_1794 inv_1844 mux_1902 0 NMOS l=6.000000000000001e-08 w=2.0000000000000002e-07
MP1904 mux_1794 xor_1270 mux_1902 VDD PMOS l=6.000000000000001e-08 w=4.0000000000000003e-07
MN1905 mux_1754 xor_1270 mux_1902 0 NMOS l=6.000000000000001e-08 w=2.0000000000000002e-07
MP1906 mux_1754 inv_1844 mux_1902 VDD PMOS l=6.000000000000001e-08 w=4.0000000000000003e-07
MN1908 mux_1799 inv_1844 mux_1907 0 NMOS l=6.000000000000001e-08 w=2.0000000000000002e-07
MP1909 mux_1799 xor_1270 mux_1907 VDD PMOS l=6.000000000000001e-08 w=4.0000000000000003e-07
MN1910 mux_1759 xor_1270 mux_1907 0 NMOS l=6.000000000000001e-08 w=2.0000000000000002e-07
MP1911 mux_1759 inv_1844 mux_1907 VDD PMOS l=6.000000000000001e-08 w=4.0000000000000003e-07
MN1913 mux_1804 inv_1844 mux_1912 0 NMOS l=6.000000000000001e-08 w=2.0000000000000002e-07
MP1914 mux_1804 xor_1270 mux_1912 VDD PMOS l=6.000000000000001e-08 w=4.0000000000000003e-07
MN1915 mux_1764 xor_1270 mux_1912 0 NMOS l=6.000000000000001e-08 w=2.0000000000000002e-07
MP1916 mux_1764 inv_1844 mux_1912 VDD PMOS l=6.000000000000001e-08 w=4.0000000000000003e-07
MN1918 mux_1809 inv_1844 mux_1917 0 NMOS l=6.000000000000001e-08 w=2.0000000000000002e-07
MP1919 mux_1809 xor_1270 mux_1917 VDD PMOS l=6.000000000000001e-08 w=4.0000000000000003e-07
MN1920 mux_1769 xor_1270 mux_1917 0 NMOS l=6.000000000000001e-08 w=2.0000000000000002e-07
MP1921 mux_1769 inv_1844 mux_1917 VDD PMOS l=6.000000000000001e-08 w=4.0000000000000003e-07
MN1923 mux_1814 inv_1844 mux_1922 0 NMOS l=6.000000000000001e-08 w=2.0000000000000002e-07
MP1924 mux_1814 xor_1270 mux_1922 VDD PMOS l=6.000000000000001e-08 w=4.0000000000000003e-07
MN1925 mux_1774 xor_1270 mux_1922 0 NMOS l=6.000000000000001e-08 w=2.0000000000000002e-07
MP1926 mux_1774 inv_1844 mux_1922 VDD PMOS l=6.000000000000001e-08 w=4.0000000000000003e-07
MN1928 mux_1819 inv_1844 mux_1927 0 NMOS l=6.000000000000001e-08 w=2.0000000000000002e-07
MP1929 mux_1819 xor_1270 mux_1927 VDD PMOS l=6.000000000000001e-08 w=4.0000000000000003e-07
MN1930 mux_1779 xor_1270 mux_1927 0 NMOS l=6.000000000000001e-08 w=2.0000000000000002e-07
MP1931 mux_1779 inv_1844 mux_1927 VDD PMOS l=6.000000000000001e-08 w=4.0000000000000003e-07
MN1933 mux_1824 inv_1844 mux_1932 0 NMOS l=6.000000000000001e-08 w=2.0000000000000002e-07
MP1934 mux_1824 xor_1270 mux_1932 VDD PMOS l=6.000000000000001e-08 w=4.0000000000000003e-07
MN1935 mux_1784 xor_1270 mux_1932 0 NMOS l=6.000000000000001e-08 w=2.0000000000000002e-07
MP1936 mux_1784 inv_1844 mux_1932 VDD PMOS l=6.000000000000001e-08 w=4.0000000000000003e-07
MN1938 mux_1829 inv_1844 mux_1937 0 NMOS l=6.000000000000001e-08 w=2.0000000000000002e-07
MP1939 mux_1829 xor_1270 mux_1937 VDD PMOS l=6.000000000000001e-08 w=4.0000000000000003e-07
MN1940 mux_1789 xor_1270 mux_1937 0 NMOS l=6.000000000000001e-08 w=2.0000000000000002e-07
MP1941 mux_1789 inv_1844 mux_1937 VDD PMOS l=6.000000000000001e-08 w=4.0000000000000003e-07
MN1943 mux_1834 inv_1844 mux_1942 0 NMOS l=6.000000000000001e-08 w=2.0000000000000002e-07
MP1944 mux_1834 xor_1270 mux_1942 VDD PMOS l=6.000000000000001e-08 w=4.0000000000000003e-07
MN1945 mux_1794 xor_1270 mux_1942 0 NMOS l=6.000000000000001e-08 w=2.0000000000000002e-07
MP1946 mux_1794 inv_1844 mux_1942 VDD PMOS l=6.000000000000001e-08 w=4.0000000000000003e-07
MN1948 mux_1839 inv_1844 mux_1947 0 NMOS l=6.000000000000001e-08 w=2.0000000000000002e-07
MP1949 mux_1839 xor_1270 mux_1947 VDD PMOS l=6.000000000000001e-08 w=4.0000000000000003e-07
MN1950 mux_1799 xor_1270 mux_1947 0 NMOS l=6.000000000000001e-08 w=2.0000000000000002e-07
MP1951 mux_1799 inv_1844 mux_1947 VDD PMOS l=6.000000000000001e-08 w=4.0000000000000003e-07
MP1954 nor_1952 inv_1319 nu_1953 VDD PMOS l=6.000000000000001e-08 w=4.0000000000000003e-07
MP1955 nu_1953 inv_249 VDD VDD PMOS l=6.000000000000001e-08 w=4.0000000000000003e-07
MN1956 nor_1952 inv_1319 0 0 NMOS l=6.000000000000001e-08 w=2.0000000000000002e-07
MN1957 nor_1952 inv_249 0 0 NMOS l=6.000000000000001e-08 w=2.0000000000000002e-07
MP1959 inv_1958 nor_1952 VDD VDD PMOS l=6.000000000000001e-08 w=4.0000000000000003e-07
MN1960 inv_1958 nor_1952 0 0 NMOS l=6.000000000000001e-08 w=2.0000000000000002e-07
MP1962 inv_1961 inv_1958 VDD VDD PMOS l=6.000000000000001e-08 w=4.0000000000000003e-07
MN1963 inv_1961 inv_1958 0 0 NMOS l=6.000000000000001e-08 w=2.0000000000000002e-07
MP1965 inv_1964 inv_249 VDD VDD PMOS l=6.000000000000001e-08 w=4.0000000000000003e-07
MN1966 inv_1964 inv_249 0 0 NMOS l=6.000000000000001e-08 w=2.0000000000000002e-07
MP1968 nand_1967 inv_1517 VDD VDD PMOS l=6.000000000000001e-08 w=4.0000000000000003e-07
MP1969 nand_1967 inv_1964 VDD VDD PMOS l=6.000000000000001e-08 w=4.0000000000000003e-07
MN1971 nand_1967 inv_1517 nd_1970 0 NMOS l=6.000000000000001e-08 w=2.0000000000000002e-07
MN1972 nd_1970 inv_1964 0 0 NMOS l=6.000000000000001e-08 w=2.0000000000000002e-07
MP1974 inv_1973 nand_1967 VDD VDD PMOS l=6.000000000000001e-08 w=4.0000000000000003e-07
MN1975 inv_1973 nand_1967 0 0 NMOS l=6.000000000000001e-08 w=2.0000000000000002e-07
MP1977 nand_1976 mux_1877 VDD VDD PMOS l=6.000000000000001e-08 w=4.0000000000000003e-07
MP1978 nand_1976 inv_1961 VDD VDD PMOS l=6.000000000000001e-08 w=4.0000000000000003e-07
MN1980 nand_1976 mux_1877 nd_1979 0 NMOS l=6.000000000000001e-08 w=2.0000000000000002e-07
MN1981 nd_1979 inv_1961 0 0 NMOS l=6.000000000000001e-08 w=2.0000000000000002e-07
MP1983 inv_1982 nand_1976 VDD VDD PMOS l=6.000000000000001e-08 w=4.0000000000000003e-07
MN1984 inv_1982 nand_1976 0 0 NMOS l=6.000000000000001e-08 w=2.0000000000000002e-07
MP1987 nor_1985 inv_1982 nu_1986 VDD PMOS l=6.000000000000001e-08 w=4.0000000000000003e-07
MP1988 nu_1986 inv_1973 VDD VDD PMOS l=6.000000000000001e-08 w=4.0000000000000003e-07
MN1989 nor_1985 inv_1982 0 0 NMOS l=6.000000000000001e-08 w=2.0000000000000002e-07
MN1990 nor_1985 inv_1973 0 0 NMOS l=6.000000000000001e-08 w=2.0000000000000002e-07
MP1992 inv_1991 nor_1985 VDD VDD PMOS l=6.000000000000001e-08 w=4.0000000000000003e-07
MN1993 inv_1991 nor_1985 0 0 NMOS l=6.000000000000001e-08 w=2.0000000000000002e-07
MP1995 nand_1994 mux_1882 VDD VDD PMOS l=6.000000000000001e-08 w=4.0000000000000003e-07
MP1996 nand_1994 inv_1961 VDD VDD PMOS l=6.000000000000001e-08 w=4.0000000000000003e-07
MN1998 nand_1994 mux_1882 nd_1997 0 NMOS l=6.000000000000001e-08 w=2.0000000000000002e-07
MN1999 nd_1997 inv_1961 0 0 NMOS l=6.000000000000001e-08 w=2.0000000000000002e-07
MP2001 inv_2000 nand_1994 VDD VDD PMOS l=6.000000000000001e-08 w=4.0000000000000003e-07
MN2002 inv_2000 nand_1994 0 0 NMOS l=6.000000000000001e-08 w=2.0000000000000002e-07
MP2005 nor_2003 inv_2000 nu_2004 VDD PMOS l=6.000000000000001e-08 w=4.0000000000000003e-07
MP2006 nu_2004 inv_1973 VDD VDD PMOS l=6.000000000000001e-08 w=4.0000000000000003e-07
MN2007 nor_2003 inv_2000 0 0 NMOS l=6.000000000000001e-08 w=2.0000000000000002e-07
MN2008 nor_2003 inv_1973 0 0 NMOS l=6.000000000000001e-08 w=2.0000000000000002e-07
MP2010 inv_2009 nor_2003 VDD VDD PMOS l=6.000000000000001e-08 w=4.0000000000000003e-07
MN2011 inv_2009 nor_2003 0 0 NMOS l=6.000000000000001e-08 w=2.0000000000000002e-07
MP2013 nand_2012 mux_1887 VDD VDD PMOS l=6.000000000000001e-08 w=4.0000000000000003e-07
MP2014 nand_2012 inv_1961 VDD VDD PMOS l=6.000000000000001e-08 w=4.0000000000000003e-07
MN2016 nand_2012 mux_1887 nd_2015 0 NMOS l=6.000000000000001e-08 w=2.0000000000000002e-07
MN2017 nd_2015 inv_1961 0 0 NMOS l=6.000000000000001e-08 w=2.0000000000000002e-07
MP2019 inv_2018 nand_2012 VDD VDD PMOS l=6.000000000000001e-08 w=4.0000000000000003e-07
MN2020 inv_2018 nand_2012 0 0 NMOS l=6.000000000000001e-08 w=2.0000000000000002e-07
MP2023 nor_2021 inv_2018 nu_2022 VDD PMOS l=6.000000000000001e-08 w=4.0000000000000003e-07
MP2024 nu_2022 inv_1973 VDD VDD PMOS l=6.000000000000001e-08 w=4.0000000000000003e-07
MN2025 nor_2021 inv_2018 0 0 NMOS l=6.000000000000001e-08 w=2.0000000000000002e-07
MN2026 nor_2021 inv_1973 0 0 NMOS l=6.000000000000001e-08 w=2.0000000000000002e-07
MP2028 inv_2027 nor_2021 VDD VDD PMOS l=6.000000000000001e-08 w=4.0000000000000003e-07
MN2029 inv_2027 nor_2021 0 0 NMOS l=6.000000000000001e-08 w=2.0000000000000002e-07
MP2031 nand_2030 mux_1892 VDD VDD PMOS l=6.000000000000001e-08 w=4.0000000000000003e-07
MP2032 nand_2030 inv_1961 VDD VDD PMOS l=6.000000000000001e-08 w=4.0000000000000003e-07
MN2034 nand_2030 mux_1892 nd_2033 0 NMOS l=6.000000000000001e-08 w=2.0000000000000002e-07
MN2035 nd_2033 inv_1961 0 0 NMOS l=6.000000000000001e-08 w=2.0000000000000002e-07
MP2037 inv_2036 nand_2030 VDD VDD PMOS l=6.000000000000001e-08 w=4.0000000000000003e-07
MN2038 inv_2036 nand_2030 0 0 NMOS l=6.000000000000001e-08 w=2.0000000000000002e-07
MP2041 nor_2039 inv_2036 nu_2040 VDD PMOS l=6.000000000000001e-08 w=4.0000000000000003e-07
MP2042 nu_2040 inv_1973 VDD VDD PMOS l=6.000000000000001e-08 w=4.0000000000000003e-07
MN2043 nor_2039 inv_2036 0 0 NMOS l=6.000000000000001e-08 w=2.0000000000000002e-07
MN2044 nor_2039 inv_1973 0 0 NMOS l=6.000000000000001e-08 w=2.0000000000000002e-07
MP2046 inv_2045 nor_2039 VDD VDD PMOS l=6.000000000000001e-08 w=4.0000000000000003e-07
MN2047 inv_2045 nor_2039 0 0 NMOS l=6.000000000000001e-08 w=2.0000000000000002e-07
MP2049 nand_2048 mux_1897 VDD VDD PMOS l=6.000000000000001e-08 w=4.0000000000000003e-07
MP2050 nand_2048 inv_1961 VDD VDD PMOS l=6.000000000000001e-08 w=4.0000000000000003e-07
MN2052 nand_2048 mux_1897 nd_2051 0 NMOS l=6.000000000000001e-08 w=2.0000000000000002e-07
MN2053 nd_2051 inv_1961 0 0 NMOS l=6.000000000000001e-08 w=2.0000000000000002e-07
MP2055 inv_2054 nand_2048 VDD VDD PMOS l=6.000000000000001e-08 w=4.0000000000000003e-07
MN2056 inv_2054 nand_2048 0 0 NMOS l=6.000000000000001e-08 w=2.0000000000000002e-07
MP2059 nor_2057 inv_2054 nu_2058 VDD PMOS l=6.000000000000001e-08 w=4.0000000000000003e-07
MP2060 nu_2058 inv_1973 VDD VDD PMOS l=6.000000000000001e-08 w=4.0000000000000003e-07
MN2061 nor_2057 inv_2054 0 0 NMOS l=6.000000000000001e-08 w=2.0000000000000002e-07
MN2062 nor_2057 inv_1973 0 0 NMOS l=6.000000000000001e-08 w=2.0000000000000002e-07
MP2064 inv_2063 nor_2057 VDD VDD PMOS l=6.000000000000001e-08 w=4.0000000000000003e-07
MN2065 inv_2063 nor_2057 0 0 NMOS l=6.000000000000001e-08 w=2.0000000000000002e-07
MP2067 nand_2066 mux_1902 VDD VDD PMOS l=6.000000000000001e-08 w=4.0000000000000003e-07
MP2068 nand_2066 inv_1961 VDD VDD PMOS l=6.000000000000001e-08 w=4.0000000000000003e-07
MN2070 nand_2066 mux_1902 nd_2069 0 NMOS l=6.000000000000001e-08 w=2.0000000000000002e-07
MN2071 nd_2069 inv_1961 0 0 NMOS l=6.000000000000001e-08 w=2.0000000000000002e-07
MP2073 inv_2072 nand_2066 VDD VDD PMOS l=6.000000000000001e-08 w=4.0000000000000003e-07
MN2074 inv_2072 nand_2066 0 0 NMOS l=6.000000000000001e-08 w=2.0000000000000002e-07
MP2077 nor_2075 inv_2072 nu_2076 VDD PMOS l=6.000000000000001e-08 w=4.0000000000000003e-07
MP2078 nu_2076 inv_1973 VDD VDD PMOS l=6.000000000000001e-08 w=4.0000000000000003e-07
MN2079 nor_2075 inv_2072 0 0 NMOS l=6.000000000000001e-08 w=2.0000000000000002e-07
MN2080 nor_2075 inv_1973 0 0 NMOS l=6.000000000000001e-08 w=2.0000000000000002e-07
MP2082 inv_2081 nor_2075 VDD VDD PMOS l=6.000000000000001e-08 w=4.0000000000000003e-07
MN2083 inv_2081 nor_2075 0 0 NMOS l=6.000000000000001e-08 w=2.0000000000000002e-07
MP2085 nand_2084 mux_1907 VDD VDD PMOS l=6.000000000000001e-08 w=4.0000000000000003e-07
MP2086 nand_2084 inv_1961 VDD VDD PMOS l=6.000000000000001e-08 w=4.0000000000000003e-07
MN2088 nand_2084 mux_1907 nd_2087 0 NMOS l=6.000000000000001e-08 w=2.0000000000000002e-07
MN2089 nd_2087 inv_1961 0 0 NMOS l=6.000000000000001e-08 w=2.0000000000000002e-07
MP2091 inv_2090 nand_2084 VDD VDD PMOS l=6.000000000000001e-08 w=4.0000000000000003e-07
MN2092 inv_2090 nand_2084 0 0 NMOS l=6.000000000000001e-08 w=2.0000000000000002e-07
MP2095 nor_2093 inv_2090 nu_2094 VDD PMOS l=6.000000000000001e-08 w=4.0000000000000003e-07
MP2096 nu_2094 inv_1973 VDD VDD PMOS l=6.000000000000001e-08 w=4.0000000000000003e-07
MN2097 nor_2093 inv_2090 0 0 NMOS l=6.000000000000001e-08 w=2.0000000000000002e-07
MN2098 nor_2093 inv_1973 0 0 NMOS l=6.000000000000001e-08 w=2.0000000000000002e-07
MP2100 inv_2099 nor_2093 VDD VDD PMOS l=6.000000000000001e-08 w=4.0000000000000003e-07
MN2101 inv_2099 nor_2093 0 0 NMOS l=6.000000000000001e-08 w=2.0000000000000002e-07
MP2103 nand_2102 mux_1912 VDD VDD PMOS l=6.000000000000001e-08 w=4.0000000000000003e-07
MP2104 nand_2102 inv_1961 VDD VDD PMOS l=6.000000000000001e-08 w=4.0000000000000003e-07
MN2106 nand_2102 mux_1912 nd_2105 0 NMOS l=6.000000000000001e-08 w=2.0000000000000002e-07
MN2107 nd_2105 inv_1961 0 0 NMOS l=6.000000000000001e-08 w=2.0000000000000002e-07
MP2109 inv_2108 nand_2102 VDD VDD PMOS l=6.000000000000001e-08 w=4.0000000000000003e-07
MN2110 inv_2108 nand_2102 0 0 NMOS l=6.000000000000001e-08 w=2.0000000000000002e-07
MP2113 nor_2111 inv_2108 nu_2112 VDD PMOS l=6.000000000000001e-08 w=4.0000000000000003e-07
MP2114 nu_2112 inv_1973 VDD VDD PMOS l=6.000000000000001e-08 w=4.0000000000000003e-07
MN2115 nor_2111 inv_2108 0 0 NMOS l=6.000000000000001e-08 w=2.0000000000000002e-07
MN2116 nor_2111 inv_1973 0 0 NMOS l=6.000000000000001e-08 w=2.0000000000000002e-07
MP2118 inv_2117 nor_2111 VDD VDD PMOS l=6.000000000000001e-08 w=4.0000000000000003e-07
MN2119 inv_2117 nor_2111 0 0 NMOS l=6.000000000000001e-08 w=2.0000000000000002e-07
MP2121 nand_2120 mux_1917 VDD VDD PMOS l=6.000000000000001e-08 w=4.0000000000000003e-07
MP2122 nand_2120 inv_1961 VDD VDD PMOS l=6.000000000000001e-08 w=4.0000000000000003e-07
MN2124 nand_2120 mux_1917 nd_2123 0 NMOS l=6.000000000000001e-08 w=2.0000000000000002e-07
MN2125 nd_2123 inv_1961 0 0 NMOS l=6.000000000000001e-08 w=2.0000000000000002e-07
MP2127 inv_2126 nand_2120 VDD VDD PMOS l=6.000000000000001e-08 w=4.0000000000000003e-07
MN2128 inv_2126 nand_2120 0 0 NMOS l=6.000000000000001e-08 w=2.0000000000000002e-07
MP2131 nor_2129 inv_2126 nu_2130 VDD PMOS l=6.000000000000001e-08 w=4.0000000000000003e-07
MP2132 nu_2130 inv_1973 VDD VDD PMOS l=6.000000000000001e-08 w=4.0000000000000003e-07
MN2133 nor_2129 inv_2126 0 0 NMOS l=6.000000000000001e-08 w=2.0000000000000002e-07
MN2134 nor_2129 inv_1973 0 0 NMOS l=6.000000000000001e-08 w=2.0000000000000002e-07
MP2136 inv_2135 nor_2129 VDD VDD PMOS l=6.000000000000001e-08 w=4.0000000000000003e-07
MN2137 inv_2135 nor_2129 0 0 NMOS l=6.000000000000001e-08 w=2.0000000000000002e-07
MP2139 nand_2138 mux_1922 VDD VDD PMOS l=6.000000000000001e-08 w=4.0000000000000003e-07
MP2140 nand_2138 inv_1961 VDD VDD PMOS l=6.000000000000001e-08 w=4.0000000000000003e-07
MN2142 nand_2138 mux_1922 nd_2141 0 NMOS l=6.000000000000001e-08 w=2.0000000000000002e-07
MN2143 nd_2141 inv_1961 0 0 NMOS l=6.000000000000001e-08 w=2.0000000000000002e-07
MP2145 inv_2144 nand_2138 VDD VDD PMOS l=6.000000000000001e-08 w=4.0000000000000003e-07
MN2146 inv_2144 nand_2138 0 0 NMOS l=6.000000000000001e-08 w=2.0000000000000002e-07
MP2149 nor_2147 inv_2144 nu_2148 VDD PMOS l=6.000000000000001e-08 w=4.0000000000000003e-07
MP2150 nu_2148 inv_1973 VDD VDD PMOS l=6.000000000000001e-08 w=4.0000000000000003e-07
MN2151 nor_2147 inv_2144 0 0 NMOS l=6.000000000000001e-08 w=2.0000000000000002e-07
MN2152 nor_2147 inv_1973 0 0 NMOS l=6.000000000000001e-08 w=2.0000000000000002e-07
MP2154 inv_2153 nor_2147 VDD VDD PMOS l=6.000000000000001e-08 w=4.0000000000000003e-07
MN2155 inv_2153 nor_2147 0 0 NMOS l=6.000000000000001e-08 w=2.0000000000000002e-07
MP2157 nand_2156 mux_1927 VDD VDD PMOS l=6.000000000000001e-08 w=4.0000000000000003e-07
MP2158 nand_2156 inv_1961 VDD VDD PMOS l=6.000000000000001e-08 w=4.0000000000000003e-07
MN2160 nand_2156 mux_1927 nd_2159 0 NMOS l=6.000000000000001e-08 w=2.0000000000000002e-07
MN2161 nd_2159 inv_1961 0 0 NMOS l=6.000000000000001e-08 w=2.0000000000000002e-07
MP2163 inv_2162 nand_2156 VDD VDD PMOS l=6.000000000000001e-08 w=4.0000000000000003e-07
MN2164 inv_2162 nand_2156 0 0 NMOS l=6.000000000000001e-08 w=2.0000000000000002e-07
MP2167 nor_2165 inv_2162 nu_2166 VDD PMOS l=6.000000000000001e-08 w=4.0000000000000003e-07
MP2168 nu_2166 inv_1973 VDD VDD PMOS l=6.000000000000001e-08 w=4.0000000000000003e-07
MN2169 nor_2165 inv_2162 0 0 NMOS l=6.000000000000001e-08 w=2.0000000000000002e-07
MN2170 nor_2165 inv_1973 0 0 NMOS l=6.000000000000001e-08 w=2.0000000000000002e-07
MP2172 inv_2171 nor_2165 VDD VDD PMOS l=6.000000000000001e-08 w=4.0000000000000003e-07
MN2173 inv_2171 nor_2165 0 0 NMOS l=6.000000000000001e-08 w=2.0000000000000002e-07
MP2175 nand_2174 mux_1932 VDD VDD PMOS l=6.000000000000001e-08 w=4.0000000000000003e-07
MP2176 nand_2174 inv_1961 VDD VDD PMOS l=6.000000000000001e-08 w=4.0000000000000003e-07
MN2178 nand_2174 mux_1932 nd_2177 0 NMOS l=6.000000000000001e-08 w=2.0000000000000002e-07
MN2179 nd_2177 inv_1961 0 0 NMOS l=6.000000000000001e-08 w=2.0000000000000002e-07
MP2181 inv_2180 nand_2174 VDD VDD PMOS l=6.000000000000001e-08 w=4.0000000000000003e-07
MN2182 inv_2180 nand_2174 0 0 NMOS l=6.000000000000001e-08 w=2.0000000000000002e-07
MP2185 nor_2183 inv_2180 nu_2184 VDD PMOS l=6.000000000000001e-08 w=4.0000000000000003e-07
MP2186 nu_2184 inv_1973 VDD VDD PMOS l=6.000000000000001e-08 w=4.0000000000000003e-07
MN2187 nor_2183 inv_2180 0 0 NMOS l=6.000000000000001e-08 w=2.0000000000000002e-07
MN2188 nor_2183 inv_1973 0 0 NMOS l=6.000000000000001e-08 w=2.0000000000000002e-07
MP2190 inv_2189 nor_2183 VDD VDD PMOS l=6.000000000000001e-08 w=4.0000000000000003e-07
MN2191 inv_2189 nor_2183 0 0 NMOS l=6.000000000000001e-08 w=2.0000000000000002e-07
MP2193 nand_2192 mux_1937 VDD VDD PMOS l=6.000000000000001e-08 w=4.0000000000000003e-07
MP2194 nand_2192 inv_1961 VDD VDD PMOS l=6.000000000000001e-08 w=4.0000000000000003e-07
MN2196 nand_2192 mux_1937 nd_2195 0 NMOS l=6.000000000000001e-08 w=2.0000000000000002e-07
MN2197 nd_2195 inv_1961 0 0 NMOS l=6.000000000000001e-08 w=2.0000000000000002e-07
MP2199 inv_2198 nand_2192 VDD VDD PMOS l=6.000000000000001e-08 w=4.0000000000000003e-07
MN2200 inv_2198 nand_2192 0 0 NMOS l=6.000000000000001e-08 w=2.0000000000000002e-07
MP2203 nor_2201 inv_2198 nu_2202 VDD PMOS l=6.000000000000001e-08 w=4.0000000000000003e-07
MP2204 nu_2202 inv_1973 VDD VDD PMOS l=6.000000000000001e-08 w=4.0000000000000003e-07
MN2205 nor_2201 inv_2198 0 0 NMOS l=6.000000000000001e-08 w=2.0000000000000002e-07
MN2206 nor_2201 inv_1973 0 0 NMOS l=6.000000000000001e-08 w=2.0000000000000002e-07
MP2208 inv_2207 nor_2201 VDD VDD PMOS l=6.000000000000001e-08 w=4.0000000000000003e-07
MN2209 inv_2207 nor_2201 0 0 NMOS l=6.000000000000001e-08 w=2.0000000000000002e-07
MP2211 nand_2210 mux_1942 VDD VDD PMOS l=6.000000000000001e-08 w=4.0000000000000003e-07
MP2212 nand_2210 inv_1961 VDD VDD PMOS l=6.000000000000001e-08 w=4.0000000000000003e-07
MN2214 nand_2210 mux_1942 nd_2213 0 NMOS l=6.000000000000001e-08 w=2.0000000000000002e-07
MN2215 nd_2213 inv_1961 0 0 NMOS l=6.000000000000001e-08 w=2.0000000000000002e-07
MP2217 inv_2216 nand_2210 VDD VDD PMOS l=6.000000000000001e-08 w=4.0000000000000003e-07
MN2218 inv_2216 nand_2210 0 0 NMOS l=6.000000000000001e-08 w=2.0000000000000002e-07
MP2221 nor_2219 inv_2216 nu_2220 VDD PMOS l=6.000000000000001e-08 w=4.0000000000000003e-07
MP2222 nu_2220 inv_1973 VDD VDD PMOS l=6.000000000000001e-08 w=4.0000000000000003e-07
MN2223 nor_2219 inv_2216 0 0 NMOS l=6.000000000000001e-08 w=2.0000000000000002e-07
MN2224 nor_2219 inv_1973 0 0 NMOS l=6.000000000000001e-08 w=2.0000000000000002e-07
MP2226 inv_2225 nor_2219 VDD VDD PMOS l=6.000000000000001e-08 w=4.0000000000000003e-07
MN2227 inv_2225 nor_2219 0 0 NMOS l=6.000000000000001e-08 w=2.0000000000000002e-07
MP2229 nand_2228 mux_1947 VDD VDD PMOS l=6.000000000000001e-08 w=4.0000000000000003e-07
MP2230 nand_2228 inv_1961 VDD VDD PMOS l=6.000000000000001e-08 w=4.0000000000000003e-07
MN2232 nand_2228 mux_1947 nd_2231 0 NMOS l=6.000000000000001e-08 w=2.0000000000000002e-07
MN2233 nd_2231 inv_1961 0 0 NMOS l=6.000000000000001e-08 w=2.0000000000000002e-07
MP2235 inv_2234 nand_2228 VDD VDD PMOS l=6.000000000000001e-08 w=4.0000000000000003e-07
MN2236 inv_2234 nand_2228 0 0 NMOS l=6.000000000000001e-08 w=2.0000000000000002e-07
MP2239 nor_2237 inv_2234 nu_2238 VDD PMOS l=6.000000000000001e-08 w=4.0000000000000003e-07
MP2240 nu_2238 inv_1973 VDD VDD PMOS l=6.000000000000001e-08 w=4.0000000000000003e-07
MN2241 nor_2237 inv_2234 0 0 NMOS l=6.000000000000001e-08 w=2.0000000000000002e-07
MN2242 nor_2237 inv_1973 0 0 NMOS l=6.000000000000001e-08 w=2.0000000000000002e-07
MP2244 inv_2243 nor_2237 VDD VDD PMOS l=6.000000000000001e-08 w=4.0000000000000003e-07
MN2245 inv_2243 nor_2237 0 0 NMOS l=6.000000000000001e-08 w=2.0000000000000002e-07
MP2248 inv_2247 inv_1991 VDD VDD PMOS l=6.000000000000001e-08 w=4.0000000000000003e-07
MN2249 inv_2247 inv_1991 0 0 NMOS l=6.000000000000001e-08 w=2.0000000000000002e-07
MP2251 inv_2250 xor_252 VDD VDD PMOS l=6.000000000000001e-08 w=4.0000000000000003e-07
MN2252 inv_2250 xor_252 0 0 NMOS l=6.000000000000001e-08 w=2.0000000000000002e-07
MN2253 inv_1991 inv_2250 xor_2246 0 NMOS l=6.000000000000001e-08 w=2.0000000000000002e-07
MP2254 inv_1991 xor_252 xor_2246 VDD PMOS l=6.000000000000001e-08 w=4.0000000000000003e-07
MN2255 inv_2247 xor_252 xor_2246 0 NMOS l=6.000000000000001e-08 w=2.0000000000000002e-07
MP2256 inv_2247 inv_2250 xor_2246 VDD PMOS l=6.000000000000001e-08 w=4.0000000000000003e-07
MP2259 inv_2258 inv_2009 VDD VDD PMOS l=6.000000000000001e-08 w=4.0000000000000003e-07
MN2260 inv_2258 inv_2009 0 0 NMOS l=6.000000000000001e-08 w=2.0000000000000002e-07
MP2262 inv_2261 xor_252 VDD VDD PMOS l=6.000000000000001e-08 w=4.0000000000000003e-07
MN2263 inv_2261 xor_252 0 0 NMOS l=6.000000000000001e-08 w=2.0000000000000002e-07
MN2264 inv_2009 inv_2261 xor_2257 0 NMOS l=6.000000000000001e-08 w=2.0000000000000002e-07
MP2265 inv_2009 xor_252 xor_2257 VDD PMOS l=6.000000000000001e-08 w=4.0000000000000003e-07
MN2266 inv_2258 xor_252 xor_2257 0 NMOS l=6.000000000000001e-08 w=2.0000000000000002e-07
MP2267 inv_2258 inv_2261 xor_2257 VDD PMOS l=6.000000000000001e-08 w=4.0000000000000003e-07
MP2270 inv_2269 inv_2027 VDD VDD PMOS l=6.000000000000001e-08 w=4.0000000000000003e-07
MN2271 inv_2269 inv_2027 0 0 NMOS l=6.000000000000001e-08 w=2.0000000000000002e-07
MP2273 inv_2272 xor_252 VDD VDD PMOS l=6.000000000000001e-08 w=4.0000000000000003e-07
MN2274 inv_2272 xor_252 0 0 NMOS l=6.000000000000001e-08 w=2.0000000000000002e-07
MN2275 inv_2027 inv_2272 xor_2268 0 NMOS l=6.000000000000001e-08 w=2.0000000000000002e-07
MP2276 inv_2027 xor_252 xor_2268 VDD PMOS l=6.000000000000001e-08 w=4.0000000000000003e-07
MN2277 inv_2269 xor_252 xor_2268 0 NMOS l=6.000000000000001e-08 w=2.0000000000000002e-07
MP2278 inv_2269 inv_2272 xor_2268 VDD PMOS l=6.000000000000001e-08 w=4.0000000000000003e-07
MP2281 inv_2280 inv_2045 VDD VDD PMOS l=6.000000000000001e-08 w=4.0000000000000003e-07
MN2282 inv_2280 inv_2045 0 0 NMOS l=6.000000000000001e-08 w=2.0000000000000002e-07
MP2284 inv_2283 xor_252 VDD VDD PMOS l=6.000000000000001e-08 w=4.0000000000000003e-07
MN2285 inv_2283 xor_252 0 0 NMOS l=6.000000000000001e-08 w=2.0000000000000002e-07
MN2286 inv_2045 inv_2283 xor_2279 0 NMOS l=6.000000000000001e-08 w=2.0000000000000002e-07
MP2287 inv_2045 xor_252 xor_2279 VDD PMOS l=6.000000000000001e-08 w=4.0000000000000003e-07
MN2288 inv_2280 xor_252 xor_2279 0 NMOS l=6.000000000000001e-08 w=2.0000000000000002e-07
MP2289 inv_2280 inv_2283 xor_2279 VDD PMOS l=6.000000000000001e-08 w=4.0000000000000003e-07
MP2292 inv_2291 inv_2063 VDD VDD PMOS l=6.000000000000001e-08 w=4.0000000000000003e-07
MN2293 inv_2291 inv_2063 0 0 NMOS l=6.000000000000001e-08 w=2.0000000000000002e-07
MP2295 inv_2294 xor_252 VDD VDD PMOS l=6.000000000000001e-08 w=4.0000000000000003e-07
MN2296 inv_2294 xor_252 0 0 NMOS l=6.000000000000001e-08 w=2.0000000000000002e-07
MN2297 inv_2063 inv_2294 xor_2290 0 NMOS l=6.000000000000001e-08 w=2.0000000000000002e-07
MP2298 inv_2063 xor_252 xor_2290 VDD PMOS l=6.000000000000001e-08 w=4.0000000000000003e-07
MN2299 inv_2291 xor_252 xor_2290 0 NMOS l=6.000000000000001e-08 w=2.0000000000000002e-07
MP2300 inv_2291 inv_2294 xor_2290 VDD PMOS l=6.000000000000001e-08 w=4.0000000000000003e-07
MP2303 inv_2302 inv_2081 VDD VDD PMOS l=6.000000000000001e-08 w=4.0000000000000003e-07
MN2304 inv_2302 inv_2081 0 0 NMOS l=6.000000000000001e-08 w=2.0000000000000002e-07
MP2306 inv_2305 xor_252 VDD VDD PMOS l=6.000000000000001e-08 w=4.0000000000000003e-07
MN2307 inv_2305 xor_252 0 0 NMOS l=6.000000000000001e-08 w=2.0000000000000002e-07
MN2308 inv_2081 inv_2305 xor_2301 0 NMOS l=6.000000000000001e-08 w=2.0000000000000002e-07
MP2309 inv_2081 xor_252 xor_2301 VDD PMOS l=6.000000000000001e-08 w=4.0000000000000003e-07
MN2310 inv_2302 xor_252 xor_2301 0 NMOS l=6.000000000000001e-08 w=2.0000000000000002e-07
MP2311 inv_2302 inv_2305 xor_2301 VDD PMOS l=6.000000000000001e-08 w=4.0000000000000003e-07
MP2314 inv_2313 inv_2099 VDD VDD PMOS l=6.000000000000001e-08 w=4.0000000000000003e-07
MN2315 inv_2313 inv_2099 0 0 NMOS l=6.000000000000001e-08 w=2.0000000000000002e-07
MP2317 inv_2316 xor_252 VDD VDD PMOS l=6.000000000000001e-08 w=4.0000000000000003e-07
MN2318 inv_2316 xor_252 0 0 NMOS l=6.000000000000001e-08 w=2.0000000000000002e-07
MN2319 inv_2099 inv_2316 xor_2312 0 NMOS l=6.000000000000001e-08 w=2.0000000000000002e-07
MP2320 inv_2099 xor_252 xor_2312 VDD PMOS l=6.000000000000001e-08 w=4.0000000000000003e-07
MN2321 inv_2313 xor_252 xor_2312 0 NMOS l=6.000000000000001e-08 w=2.0000000000000002e-07
MP2322 inv_2313 inv_2316 xor_2312 VDD PMOS l=6.000000000000001e-08 w=4.0000000000000003e-07
MP2325 inv_2324 inv_2117 VDD VDD PMOS l=6.000000000000001e-08 w=4.0000000000000003e-07
MN2326 inv_2324 inv_2117 0 0 NMOS l=6.000000000000001e-08 w=2.0000000000000002e-07
MP2328 inv_2327 xor_252 VDD VDD PMOS l=6.000000000000001e-08 w=4.0000000000000003e-07
MN2329 inv_2327 xor_252 0 0 NMOS l=6.000000000000001e-08 w=2.0000000000000002e-07
MN2330 inv_2117 inv_2327 xor_2323 0 NMOS l=6.000000000000001e-08 w=2.0000000000000002e-07
MP2331 inv_2117 xor_252 xor_2323 VDD PMOS l=6.000000000000001e-08 w=4.0000000000000003e-07
MN2332 inv_2324 xor_252 xor_2323 0 NMOS l=6.000000000000001e-08 w=2.0000000000000002e-07
MP2333 inv_2324 inv_2327 xor_2323 VDD PMOS l=6.000000000000001e-08 w=4.0000000000000003e-07
MP2336 inv_2335 inv_2135 VDD VDD PMOS l=6.000000000000001e-08 w=4.0000000000000003e-07
MN2337 inv_2335 inv_2135 0 0 NMOS l=6.000000000000001e-08 w=2.0000000000000002e-07
MP2339 inv_2338 xor_252 VDD VDD PMOS l=6.000000000000001e-08 w=4.0000000000000003e-07
MN2340 inv_2338 xor_252 0 0 NMOS l=6.000000000000001e-08 w=2.0000000000000002e-07
MN2341 inv_2135 inv_2338 xor_2334 0 NMOS l=6.000000000000001e-08 w=2.0000000000000002e-07
MP2342 inv_2135 xor_252 xor_2334 VDD PMOS l=6.000000000000001e-08 w=4.0000000000000003e-07
MN2343 inv_2335 xor_252 xor_2334 0 NMOS l=6.000000000000001e-08 w=2.0000000000000002e-07
MP2344 inv_2335 inv_2338 xor_2334 VDD PMOS l=6.000000000000001e-08 w=4.0000000000000003e-07
MP2347 inv_2346 inv_2153 VDD VDD PMOS l=6.000000000000001e-08 w=4.0000000000000003e-07
MN2348 inv_2346 inv_2153 0 0 NMOS l=6.000000000000001e-08 w=2.0000000000000002e-07
MP2350 inv_2349 xor_252 VDD VDD PMOS l=6.000000000000001e-08 w=4.0000000000000003e-07
MN2351 inv_2349 xor_252 0 0 NMOS l=6.000000000000001e-08 w=2.0000000000000002e-07
MN2352 inv_2153 inv_2349 xor_2345 0 NMOS l=6.000000000000001e-08 w=2.0000000000000002e-07
MP2353 inv_2153 xor_252 xor_2345 VDD PMOS l=6.000000000000001e-08 w=4.0000000000000003e-07
MN2354 inv_2346 xor_252 xor_2345 0 NMOS l=6.000000000000001e-08 w=2.0000000000000002e-07
MP2355 inv_2346 inv_2349 xor_2345 VDD PMOS l=6.000000000000001e-08 w=4.0000000000000003e-07
MP2358 inv_2357 inv_2171 VDD VDD PMOS l=6.000000000000001e-08 w=4.0000000000000003e-07
MN2359 inv_2357 inv_2171 0 0 NMOS l=6.000000000000001e-08 w=2.0000000000000002e-07
MP2361 inv_2360 xor_252 VDD VDD PMOS l=6.000000000000001e-08 w=4.0000000000000003e-07
MN2362 inv_2360 xor_252 0 0 NMOS l=6.000000000000001e-08 w=2.0000000000000002e-07
MN2363 inv_2171 inv_2360 xor_2356 0 NMOS l=6.000000000000001e-08 w=2.0000000000000002e-07
MP2364 inv_2171 xor_252 xor_2356 VDD PMOS l=6.000000000000001e-08 w=4.0000000000000003e-07
MN2365 inv_2357 xor_252 xor_2356 0 NMOS l=6.000000000000001e-08 w=2.0000000000000002e-07
MP2366 inv_2357 inv_2360 xor_2356 VDD PMOS l=6.000000000000001e-08 w=4.0000000000000003e-07
MP2369 inv_2368 inv_2189 VDD VDD PMOS l=6.000000000000001e-08 w=4.0000000000000003e-07
MN2370 inv_2368 inv_2189 0 0 NMOS l=6.000000000000001e-08 w=2.0000000000000002e-07
MP2372 inv_2371 xor_252 VDD VDD PMOS l=6.000000000000001e-08 w=4.0000000000000003e-07
MN2373 inv_2371 xor_252 0 0 NMOS l=6.000000000000001e-08 w=2.0000000000000002e-07
MN2374 inv_2189 inv_2371 xor_2367 0 NMOS l=6.000000000000001e-08 w=2.0000000000000002e-07
MP2375 inv_2189 xor_252 xor_2367 VDD PMOS l=6.000000000000001e-08 w=4.0000000000000003e-07
MN2376 inv_2368 xor_252 xor_2367 0 NMOS l=6.000000000000001e-08 w=2.0000000000000002e-07
MP2377 inv_2368 inv_2371 xor_2367 VDD PMOS l=6.000000000000001e-08 w=4.0000000000000003e-07
MP2380 inv_2379 inv_2207 VDD VDD PMOS l=6.000000000000001e-08 w=4.0000000000000003e-07
MN2381 inv_2379 inv_2207 0 0 NMOS l=6.000000000000001e-08 w=2.0000000000000002e-07
MP2383 inv_2382 xor_252 VDD VDD PMOS l=6.000000000000001e-08 w=4.0000000000000003e-07
MN2384 inv_2382 xor_252 0 0 NMOS l=6.000000000000001e-08 w=2.0000000000000002e-07
MN2385 inv_2207 inv_2382 xor_2378 0 NMOS l=6.000000000000001e-08 w=2.0000000000000002e-07
MP2386 inv_2207 xor_252 xor_2378 VDD PMOS l=6.000000000000001e-08 w=4.0000000000000003e-07
MN2387 inv_2379 xor_252 xor_2378 0 NMOS l=6.000000000000001e-08 w=2.0000000000000002e-07
MP2388 inv_2379 inv_2382 xor_2378 VDD PMOS l=6.000000000000001e-08 w=4.0000000000000003e-07
MP2391 inv_2390 inv_2225 VDD VDD PMOS l=6.000000000000001e-08 w=4.0000000000000003e-07
MN2392 inv_2390 inv_2225 0 0 NMOS l=6.000000000000001e-08 w=2.0000000000000002e-07
MP2394 inv_2393 xor_252 VDD VDD PMOS l=6.000000000000001e-08 w=4.0000000000000003e-07
MN2395 inv_2393 xor_252 0 0 NMOS l=6.000000000000001e-08 w=2.0000000000000002e-07
MN2396 inv_2225 inv_2393 xor_2389 0 NMOS l=6.000000000000001e-08 w=2.0000000000000002e-07
MP2397 inv_2225 xor_252 xor_2389 VDD PMOS l=6.000000000000001e-08 w=4.0000000000000003e-07
MN2398 inv_2390 xor_252 xor_2389 0 NMOS l=6.000000000000001e-08 w=2.0000000000000002e-07
MP2399 inv_2390 inv_2393 xor_2389 VDD PMOS l=6.000000000000001e-08 w=4.0000000000000003e-07
MP2402 inv_2401 inv_2243 VDD VDD PMOS l=6.000000000000001e-08 w=4.0000000000000003e-07
MN2403 inv_2401 inv_2243 0 0 NMOS l=6.000000000000001e-08 w=2.0000000000000002e-07
MP2405 inv_2404 xor_252 VDD VDD PMOS l=6.000000000000001e-08 w=4.0000000000000003e-07
MN2406 inv_2404 xor_252 0 0 NMOS l=6.000000000000001e-08 w=2.0000000000000002e-07
MN2407 inv_2243 inv_2404 xor_2400 0 NMOS l=6.000000000000001e-08 w=2.0000000000000002e-07
MP2408 inv_2243 xor_252 xor_2400 VDD PMOS l=6.000000000000001e-08 w=4.0000000000000003e-07
MN2409 inv_2401 xor_252 xor_2400 0 NMOS l=6.000000000000001e-08 w=2.0000000000000002e-07
MP2410 inv_2401 inv_2404 xor_2400 VDD PMOS l=6.000000000000001e-08 w=4.0000000000000003e-07
MP2413 inv_2412 GND VDD VDD PMOS l=6.000000000000001e-08 w=4.0000000000000003e-07
MN2414 inv_2412 GND 0 0 NMOS l=6.000000000000001e-08 w=2.0000000000000002e-07
MP2416 inv_2415 xor_252 VDD VDD PMOS l=6.000000000000001e-08 w=4.0000000000000003e-07
MN2417 inv_2415 xor_252 0 0 NMOS l=6.000000000000001e-08 w=2.0000000000000002e-07
MN2418 0 inv_2415 xor_2411 0 NMOS l=6.000000000000001e-08 w=2.0000000000000002e-07
MP2419 0 xor_252 xor_2411 VDD PMOS l=6.000000000000001e-08 w=4.0000000000000003e-07
MN2420 inv_2412 xor_252 xor_2411 0 NMOS l=6.000000000000001e-08 w=2.0000000000000002e-07
MP2421 inv_2412 inv_2415 xor_2411 VDD PMOS l=6.000000000000001e-08 w=4.0000000000000003e-07
MP2423 inv_2422 Cin0_17 VDD VDD PMOS l=6.000000000000001e-08 w=4.0000000000000003e-07
MN2424 inv_2422 Cin0_17 0 0 NMOS l=6.000000000000001e-08 w=2.0000000000000002e-07
MP2426 inv_2425 xor_2246 VDD VDD PMOS l=6.000000000000001e-08 w=4.0000000000000003e-07
MN2427 inv_2425 xor_2246 0 0 NMOS l=6.000000000000001e-08 w=2.0000000000000002e-07
MN2429 Cin0_17 inv_2425 xor_2428 0 NMOS l=6.000000000000001e-08 w=2.0000000000000002e-07
MP2430 Cin0_17 xor_2246 xor_2428 VDD PMOS l=6.000000000000001e-08 w=4.0000000000000003e-07
MN2431 inv_2422 xor_2246 xor_2428 0 NMOS l=6.000000000000001e-08 w=2.0000000000000002e-07
MP2432 inv_2422 inv_2425 xor_2428 VDD PMOS l=6.000000000000001e-08 w=4.0000000000000003e-07
MP2434 inv_2433 xor_2428 VDD VDD PMOS l=6.000000000000001e-08 w=4.0000000000000003e-07
MN2435 inv_2433 xor_2428 0 0 NMOS l=6.000000000000001e-08 w=2.0000000000000002e-07
MP2437 inv_2436 xor_252 VDD VDD PMOS l=6.000000000000001e-08 w=4.0000000000000003e-07
MN2438 inv_2436 xor_252 0 0 NMOS l=6.000000000000001e-08 w=2.0000000000000002e-07
MN2440 xor_2428 inv_2436 xor_2439 0 NMOS l=6.000000000000001e-08 w=2.0000000000000002e-07
MP2441 xor_2428 xor_252 xor_2439 VDD PMOS l=6.000000000000001e-08 w=4.0000000000000003e-07
MN2442 inv_2433 xor_252 xor_2439 0 NMOS l=6.000000000000001e-08 w=2.0000000000000002e-07
MP2443 inv_2433 inv_2436 xor_2439 VDD PMOS l=6.000000000000001e-08 w=4.0000000000000003e-07
MN2445 xor_252 xor_2428 cout_2444 0 NMOS l=6.000000000000001e-08 w=2.0000000000000002e-07
MP2446 xor_252 inv_2433 cout_2444 VDD PMOS l=6.000000000000001e-08 w=4.0000000000000003e-07
MN2447 Cin0_17 inv_2433 cout_2444 0 NMOS l=6.000000000000001e-08 w=2.0000000000000002e-07
MP2448 Cin0_17 xor_2428 cout_2444 VDD PMOS l=6.000000000000001e-08 w=4.0000000000000003e-07
MP2450 inv_2449 cout_2444 VDD VDD PMOS l=6.000000000000001e-08 w=4.0000000000000003e-07
MN2451 inv_2449 cout_2444 0 0 NMOS l=6.000000000000001e-08 w=2.0000000000000002e-07
MP2453 inv_2452 inv_2449 VDD VDD PMOS l=6.000000000000001e-08 w=4.0000000000000003e-07
MN2454 inv_2452 inv_2449 0 0 NMOS l=6.000000000000001e-08 w=2.0000000000000002e-07
MP2456 inv_2455 Cin1_18 VDD VDD PMOS l=6.000000000000001e-08 w=4.0000000000000003e-07
MN2457 inv_2455 Cin1_18 0 0 NMOS l=6.000000000000001e-08 w=2.0000000000000002e-07
MP2459 inv_2458 xor_2257 VDD VDD PMOS l=6.000000000000001e-08 w=4.0000000000000003e-07
MN2460 inv_2458 xor_2257 0 0 NMOS l=6.000000000000001e-08 w=2.0000000000000002e-07
MN2462 Cin1_18 inv_2458 xor_2461 0 NMOS l=6.000000000000001e-08 w=2.0000000000000002e-07
MP2463 Cin1_18 xor_2257 xor_2461 VDD PMOS l=6.000000000000001e-08 w=4.0000000000000003e-07
MN2464 inv_2455 xor_2257 xor_2461 0 NMOS l=6.000000000000001e-08 w=2.0000000000000002e-07
MP2465 inv_2455 inv_2458 xor_2461 VDD PMOS l=6.000000000000001e-08 w=4.0000000000000003e-07
MP2467 inv_2466 xor_2461 VDD VDD PMOS l=6.000000000000001e-08 w=4.0000000000000003e-07
MN2468 inv_2466 xor_2461 0 0 NMOS l=6.000000000000001e-08 w=2.0000000000000002e-07
MP2470 inv_2469 inv_2452 VDD VDD PMOS l=6.000000000000001e-08 w=4.0000000000000003e-07
MN2471 inv_2469 inv_2452 0 0 NMOS l=6.000000000000001e-08 w=2.0000000000000002e-07
MN2473 xor_2461 inv_2469 xor_2472 0 NMOS l=6.000000000000001e-08 w=2.0000000000000002e-07
MP2474 xor_2461 inv_2452 xor_2472 VDD PMOS l=6.000000000000001e-08 w=4.0000000000000003e-07
MN2475 inv_2466 inv_2452 xor_2472 0 NMOS l=6.000000000000001e-08 w=2.0000000000000002e-07
MP2476 inv_2466 inv_2469 xor_2472 VDD PMOS l=6.000000000000001e-08 w=4.0000000000000003e-07
MN2478 inv_2452 xor_2461 cout_2477 0 NMOS l=6.000000000000001e-08 w=2.0000000000000002e-07
MP2479 inv_2452 inv_2466 cout_2477 VDD PMOS l=6.000000000000001e-08 w=4.0000000000000003e-07
MN2480 Cin1_18 inv_2466 cout_2477 0 NMOS l=6.000000000000001e-08 w=2.0000000000000002e-07
MP2481 Cin1_18 xor_2461 cout_2477 VDD PMOS l=6.000000000000001e-08 w=4.0000000000000003e-07
MP2483 inv_2482 cout_2477 VDD VDD PMOS l=6.000000000000001e-08 w=4.0000000000000003e-07
MN2484 inv_2482 cout_2477 0 0 NMOS l=6.000000000000001e-08 w=2.0000000000000002e-07
MP2486 inv_2485 inv_2482 VDD VDD PMOS l=6.000000000000001e-08 w=4.0000000000000003e-07
MN2487 inv_2485 inv_2482 0 0 NMOS l=6.000000000000001e-08 w=2.0000000000000002e-07
MP2489 inv_2488 Cin2_19 VDD VDD PMOS l=6.000000000000001e-08 w=4.0000000000000003e-07
MN2490 inv_2488 Cin2_19 0 0 NMOS l=6.000000000000001e-08 w=2.0000000000000002e-07
MP2492 inv_2491 xor_2268 VDD VDD PMOS l=6.000000000000001e-08 w=4.0000000000000003e-07
MN2493 inv_2491 xor_2268 0 0 NMOS l=6.000000000000001e-08 w=2.0000000000000002e-07
MN2495 Cin2_19 inv_2491 xor_2494 0 NMOS l=6.000000000000001e-08 w=2.0000000000000002e-07
MP2496 Cin2_19 xor_2268 xor_2494 VDD PMOS l=6.000000000000001e-08 w=4.0000000000000003e-07
MN2497 inv_2488 xor_2268 xor_2494 0 NMOS l=6.000000000000001e-08 w=2.0000000000000002e-07
MP2498 inv_2488 inv_2491 xor_2494 VDD PMOS l=6.000000000000001e-08 w=4.0000000000000003e-07
MP2500 inv_2499 xor_2494 VDD VDD PMOS l=6.000000000000001e-08 w=4.0000000000000003e-07
MN2501 inv_2499 xor_2494 0 0 NMOS l=6.000000000000001e-08 w=2.0000000000000002e-07
MP2503 inv_2502 inv_2485 VDD VDD PMOS l=6.000000000000001e-08 w=4.0000000000000003e-07
MN2504 inv_2502 inv_2485 0 0 NMOS l=6.000000000000001e-08 w=2.0000000000000002e-07
MN2506 xor_2494 inv_2502 xor_2505 0 NMOS l=6.000000000000001e-08 w=2.0000000000000002e-07
MP2507 xor_2494 inv_2485 xor_2505 VDD PMOS l=6.000000000000001e-08 w=4.0000000000000003e-07
MN2508 inv_2499 inv_2485 xor_2505 0 NMOS l=6.000000000000001e-08 w=2.0000000000000002e-07
MP2509 inv_2499 inv_2502 xor_2505 VDD PMOS l=6.000000000000001e-08 w=4.0000000000000003e-07
MN2511 inv_2485 xor_2494 cout_2510 0 NMOS l=6.000000000000001e-08 w=2.0000000000000002e-07
MP2512 inv_2485 inv_2499 cout_2510 VDD PMOS l=6.000000000000001e-08 w=4.0000000000000003e-07
MN2513 Cin2_19 inv_2499 cout_2510 0 NMOS l=6.000000000000001e-08 w=2.0000000000000002e-07
MP2514 Cin2_19 xor_2494 cout_2510 VDD PMOS l=6.000000000000001e-08 w=4.0000000000000003e-07
MP2516 inv_2515 cout_2510 VDD VDD PMOS l=6.000000000000001e-08 w=4.0000000000000003e-07
MN2517 inv_2515 cout_2510 0 0 NMOS l=6.000000000000001e-08 w=2.0000000000000002e-07
MP2519 inv_2518 inv_2515 VDD VDD PMOS l=6.000000000000001e-08 w=4.0000000000000003e-07
MN2520 inv_2518 inv_2515 0 0 NMOS l=6.000000000000001e-08 w=2.0000000000000002e-07
MP2522 inv_2521 Cin3_20 VDD VDD PMOS l=6.000000000000001e-08 w=4.0000000000000003e-07
MN2523 inv_2521 Cin3_20 0 0 NMOS l=6.000000000000001e-08 w=2.0000000000000002e-07
MP2525 inv_2524 xor_2279 VDD VDD PMOS l=6.000000000000001e-08 w=4.0000000000000003e-07
MN2526 inv_2524 xor_2279 0 0 NMOS l=6.000000000000001e-08 w=2.0000000000000002e-07
MN2528 Cin3_20 inv_2524 xor_2527 0 NMOS l=6.000000000000001e-08 w=2.0000000000000002e-07
MP2529 Cin3_20 xor_2279 xor_2527 VDD PMOS l=6.000000000000001e-08 w=4.0000000000000003e-07
MN2530 inv_2521 xor_2279 xor_2527 0 NMOS l=6.000000000000001e-08 w=2.0000000000000002e-07
MP2531 inv_2521 inv_2524 xor_2527 VDD PMOS l=6.000000000000001e-08 w=4.0000000000000003e-07
MP2533 inv_2532 xor_2527 VDD VDD PMOS l=6.000000000000001e-08 w=4.0000000000000003e-07
MN2534 inv_2532 xor_2527 0 0 NMOS l=6.000000000000001e-08 w=2.0000000000000002e-07
MP2536 inv_2535 inv_2518 VDD VDD PMOS l=6.000000000000001e-08 w=4.0000000000000003e-07
MN2537 inv_2535 inv_2518 0 0 NMOS l=6.000000000000001e-08 w=2.0000000000000002e-07
MN2539 xor_2527 inv_2535 xor_2538 0 NMOS l=6.000000000000001e-08 w=2.0000000000000002e-07
MP2540 xor_2527 inv_2518 xor_2538 VDD PMOS l=6.000000000000001e-08 w=4.0000000000000003e-07
MN2541 inv_2532 inv_2518 xor_2538 0 NMOS l=6.000000000000001e-08 w=2.0000000000000002e-07
MP2542 inv_2532 inv_2535 xor_2538 VDD PMOS l=6.000000000000001e-08 w=4.0000000000000003e-07
MN2544 inv_2518 xor_2527 cout_2543 0 NMOS l=6.000000000000001e-08 w=2.0000000000000002e-07
MP2545 inv_2518 inv_2532 cout_2543 VDD PMOS l=6.000000000000001e-08 w=4.0000000000000003e-07
MN2546 Cin3_20 inv_2532 cout_2543 0 NMOS l=6.000000000000001e-08 w=2.0000000000000002e-07
MP2547 Cin3_20 xor_2527 cout_2543 VDD PMOS l=6.000000000000001e-08 w=4.0000000000000003e-07
MP2549 inv_2548 cout_2543 VDD VDD PMOS l=6.000000000000001e-08 w=4.0000000000000003e-07
MN2550 inv_2548 cout_2543 0 0 NMOS l=6.000000000000001e-08 w=2.0000000000000002e-07
MP2552 inv_2551 inv_2548 VDD VDD PMOS l=6.000000000000001e-08 w=4.0000000000000003e-07
MN2553 inv_2551 inv_2548 0 0 NMOS l=6.000000000000001e-08 w=2.0000000000000002e-07
MP2555 inv_2554 Cin4_21 VDD VDD PMOS l=6.000000000000001e-08 w=4.0000000000000003e-07
MN2556 inv_2554 Cin4_21 0 0 NMOS l=6.000000000000001e-08 w=2.0000000000000002e-07
MP2558 inv_2557 xor_2290 VDD VDD PMOS l=6.000000000000001e-08 w=4.0000000000000003e-07
MN2559 inv_2557 xor_2290 0 0 NMOS l=6.000000000000001e-08 w=2.0000000000000002e-07
MN2561 Cin4_21 inv_2557 xor_2560 0 NMOS l=6.000000000000001e-08 w=2.0000000000000002e-07
MP2562 Cin4_21 xor_2290 xor_2560 VDD PMOS l=6.000000000000001e-08 w=4.0000000000000003e-07
MN2563 inv_2554 xor_2290 xor_2560 0 NMOS l=6.000000000000001e-08 w=2.0000000000000002e-07
MP2564 inv_2554 inv_2557 xor_2560 VDD PMOS l=6.000000000000001e-08 w=4.0000000000000003e-07
MP2566 inv_2565 xor_2560 VDD VDD PMOS l=6.000000000000001e-08 w=4.0000000000000003e-07
MN2567 inv_2565 xor_2560 0 0 NMOS l=6.000000000000001e-08 w=2.0000000000000002e-07
MP2569 inv_2568 inv_2551 VDD VDD PMOS l=6.000000000000001e-08 w=4.0000000000000003e-07
MN2570 inv_2568 inv_2551 0 0 NMOS l=6.000000000000001e-08 w=2.0000000000000002e-07
MN2572 xor_2560 inv_2568 xor_2571 0 NMOS l=6.000000000000001e-08 w=2.0000000000000002e-07
MP2573 xor_2560 inv_2551 xor_2571 VDD PMOS l=6.000000000000001e-08 w=4.0000000000000003e-07
MN2574 inv_2565 inv_2551 xor_2571 0 NMOS l=6.000000000000001e-08 w=2.0000000000000002e-07
MP2575 inv_2565 inv_2568 xor_2571 VDD PMOS l=6.000000000000001e-08 w=4.0000000000000003e-07
MN2577 inv_2551 xor_2560 cout_2576 0 NMOS l=6.000000000000001e-08 w=2.0000000000000002e-07
MP2578 inv_2551 inv_2565 cout_2576 VDD PMOS l=6.000000000000001e-08 w=4.0000000000000003e-07
MN2579 Cin4_21 inv_2565 cout_2576 0 NMOS l=6.000000000000001e-08 w=2.0000000000000002e-07
MP2580 Cin4_21 xor_2560 cout_2576 VDD PMOS l=6.000000000000001e-08 w=4.0000000000000003e-07
MP2582 inv_2581 cout_2576 VDD VDD PMOS l=6.000000000000001e-08 w=4.0000000000000003e-07
MN2583 inv_2581 cout_2576 0 0 NMOS l=6.000000000000001e-08 w=2.0000000000000002e-07
MP2585 inv_2584 inv_2581 VDD VDD PMOS l=6.000000000000001e-08 w=4.0000000000000003e-07
MN2586 inv_2584 inv_2581 0 0 NMOS l=6.000000000000001e-08 w=2.0000000000000002e-07
MP2588 inv_2587 Cin5_22 VDD VDD PMOS l=6.000000000000001e-08 w=4.0000000000000003e-07
MN2589 inv_2587 Cin5_22 0 0 NMOS l=6.000000000000001e-08 w=2.0000000000000002e-07
MP2591 inv_2590 xor_2301 VDD VDD PMOS l=6.000000000000001e-08 w=4.0000000000000003e-07
MN2592 inv_2590 xor_2301 0 0 NMOS l=6.000000000000001e-08 w=2.0000000000000002e-07
MN2594 Cin5_22 inv_2590 xor_2593 0 NMOS l=6.000000000000001e-08 w=2.0000000000000002e-07
MP2595 Cin5_22 xor_2301 xor_2593 VDD PMOS l=6.000000000000001e-08 w=4.0000000000000003e-07
MN2596 inv_2587 xor_2301 xor_2593 0 NMOS l=6.000000000000001e-08 w=2.0000000000000002e-07
MP2597 inv_2587 inv_2590 xor_2593 VDD PMOS l=6.000000000000001e-08 w=4.0000000000000003e-07
MP2599 inv_2598 xor_2593 VDD VDD PMOS l=6.000000000000001e-08 w=4.0000000000000003e-07
MN2600 inv_2598 xor_2593 0 0 NMOS l=6.000000000000001e-08 w=2.0000000000000002e-07
MP2602 inv_2601 inv_2584 VDD VDD PMOS l=6.000000000000001e-08 w=4.0000000000000003e-07
MN2603 inv_2601 inv_2584 0 0 NMOS l=6.000000000000001e-08 w=2.0000000000000002e-07
MN2605 xor_2593 inv_2601 xor_2604 0 NMOS l=6.000000000000001e-08 w=2.0000000000000002e-07
MP2606 xor_2593 inv_2584 xor_2604 VDD PMOS l=6.000000000000001e-08 w=4.0000000000000003e-07
MN2607 inv_2598 inv_2584 xor_2604 0 NMOS l=6.000000000000001e-08 w=2.0000000000000002e-07
MP2608 inv_2598 inv_2601 xor_2604 VDD PMOS l=6.000000000000001e-08 w=4.0000000000000003e-07
MN2610 inv_2584 xor_2593 cout_2609 0 NMOS l=6.000000000000001e-08 w=2.0000000000000002e-07
MP2611 inv_2584 inv_2598 cout_2609 VDD PMOS l=6.000000000000001e-08 w=4.0000000000000003e-07
MN2612 Cin5_22 inv_2598 cout_2609 0 NMOS l=6.000000000000001e-08 w=2.0000000000000002e-07
MP2613 Cin5_22 xor_2593 cout_2609 VDD PMOS l=6.000000000000001e-08 w=4.0000000000000003e-07
MP2615 inv_2614 cout_2609 VDD VDD PMOS l=6.000000000000001e-08 w=4.0000000000000003e-07
MN2616 inv_2614 cout_2609 0 0 NMOS l=6.000000000000001e-08 w=2.0000000000000002e-07
MP2618 inv_2617 inv_2614 VDD VDD PMOS l=6.000000000000001e-08 w=4.0000000000000003e-07
MN2619 inv_2617 inv_2614 0 0 NMOS l=6.000000000000001e-08 w=2.0000000000000002e-07
MP2621 inv_2620 Cin6_23 VDD VDD PMOS l=6.000000000000001e-08 w=4.0000000000000003e-07
MN2622 inv_2620 Cin6_23 0 0 NMOS l=6.000000000000001e-08 w=2.0000000000000002e-07
MP2624 inv_2623 xor_2312 VDD VDD PMOS l=6.000000000000001e-08 w=4.0000000000000003e-07
MN2625 inv_2623 xor_2312 0 0 NMOS l=6.000000000000001e-08 w=2.0000000000000002e-07
MN2627 Cin6_23 inv_2623 xor_2626 0 NMOS l=6.000000000000001e-08 w=2.0000000000000002e-07
MP2628 Cin6_23 xor_2312 xor_2626 VDD PMOS l=6.000000000000001e-08 w=4.0000000000000003e-07
MN2629 inv_2620 xor_2312 xor_2626 0 NMOS l=6.000000000000001e-08 w=2.0000000000000002e-07
MP2630 inv_2620 inv_2623 xor_2626 VDD PMOS l=6.000000000000001e-08 w=4.0000000000000003e-07
MP2632 inv_2631 xor_2626 VDD VDD PMOS l=6.000000000000001e-08 w=4.0000000000000003e-07
MN2633 inv_2631 xor_2626 0 0 NMOS l=6.000000000000001e-08 w=2.0000000000000002e-07
MP2635 inv_2634 inv_2617 VDD VDD PMOS l=6.000000000000001e-08 w=4.0000000000000003e-07
MN2636 inv_2634 inv_2617 0 0 NMOS l=6.000000000000001e-08 w=2.0000000000000002e-07
MN2638 xor_2626 inv_2634 xor_2637 0 NMOS l=6.000000000000001e-08 w=2.0000000000000002e-07
MP2639 xor_2626 inv_2617 xor_2637 VDD PMOS l=6.000000000000001e-08 w=4.0000000000000003e-07
MN2640 inv_2631 inv_2617 xor_2637 0 NMOS l=6.000000000000001e-08 w=2.0000000000000002e-07
MP2641 inv_2631 inv_2634 xor_2637 VDD PMOS l=6.000000000000001e-08 w=4.0000000000000003e-07
MN2643 inv_2617 xor_2626 cout_2642 0 NMOS l=6.000000000000001e-08 w=2.0000000000000002e-07
MP2644 inv_2617 inv_2631 cout_2642 VDD PMOS l=6.000000000000001e-08 w=4.0000000000000003e-07
MN2645 Cin6_23 inv_2631 cout_2642 0 NMOS l=6.000000000000001e-08 w=2.0000000000000002e-07
MP2646 Cin6_23 xor_2626 cout_2642 VDD PMOS l=6.000000000000001e-08 w=4.0000000000000003e-07
MP2648 inv_2647 cout_2642 VDD VDD PMOS l=6.000000000000001e-08 w=4.0000000000000003e-07
MN2649 inv_2647 cout_2642 0 0 NMOS l=6.000000000000001e-08 w=2.0000000000000002e-07
MP2651 inv_2650 inv_2647 VDD VDD PMOS l=6.000000000000001e-08 w=4.0000000000000003e-07
MN2652 inv_2650 inv_2647 0 0 NMOS l=6.000000000000001e-08 w=2.0000000000000002e-07
MP2654 inv_2653 Cin7_24 VDD VDD PMOS l=6.000000000000001e-08 w=4.0000000000000003e-07
MN2655 inv_2653 Cin7_24 0 0 NMOS l=6.000000000000001e-08 w=2.0000000000000002e-07
MP2657 inv_2656 xor_2323 VDD VDD PMOS l=6.000000000000001e-08 w=4.0000000000000003e-07
MN2658 inv_2656 xor_2323 0 0 NMOS l=6.000000000000001e-08 w=2.0000000000000002e-07
MN2660 Cin7_24 inv_2656 xor_2659 0 NMOS l=6.000000000000001e-08 w=2.0000000000000002e-07
MP2661 Cin7_24 xor_2323 xor_2659 VDD PMOS l=6.000000000000001e-08 w=4.0000000000000003e-07
MN2662 inv_2653 xor_2323 xor_2659 0 NMOS l=6.000000000000001e-08 w=2.0000000000000002e-07
MP2663 inv_2653 inv_2656 xor_2659 VDD PMOS l=6.000000000000001e-08 w=4.0000000000000003e-07
MP2665 inv_2664 xor_2659 VDD VDD PMOS l=6.000000000000001e-08 w=4.0000000000000003e-07
MN2666 inv_2664 xor_2659 0 0 NMOS l=6.000000000000001e-08 w=2.0000000000000002e-07
MP2668 inv_2667 inv_2650 VDD VDD PMOS l=6.000000000000001e-08 w=4.0000000000000003e-07
MN2669 inv_2667 inv_2650 0 0 NMOS l=6.000000000000001e-08 w=2.0000000000000002e-07
MN2671 xor_2659 inv_2667 xor_2670 0 NMOS l=6.000000000000001e-08 w=2.0000000000000002e-07
MP2672 xor_2659 inv_2650 xor_2670 VDD PMOS l=6.000000000000001e-08 w=4.0000000000000003e-07
MN2673 inv_2664 inv_2650 xor_2670 0 NMOS l=6.000000000000001e-08 w=2.0000000000000002e-07
MP2674 inv_2664 inv_2667 xor_2670 VDD PMOS l=6.000000000000001e-08 w=4.0000000000000003e-07
MN2676 inv_2650 xor_2659 cout_2675 0 NMOS l=6.000000000000001e-08 w=2.0000000000000002e-07
MP2677 inv_2650 inv_2664 cout_2675 VDD PMOS l=6.000000000000001e-08 w=4.0000000000000003e-07
MN2678 Cin7_24 inv_2664 cout_2675 0 NMOS l=6.000000000000001e-08 w=2.0000000000000002e-07
MP2679 Cin7_24 xor_2659 cout_2675 VDD PMOS l=6.000000000000001e-08 w=4.0000000000000003e-07
MP2681 inv_2680 cout_2675 VDD VDD PMOS l=6.000000000000001e-08 w=4.0000000000000003e-07
MN2682 inv_2680 cout_2675 0 0 NMOS l=6.000000000000001e-08 w=2.0000000000000002e-07
MP2684 inv_2683 inv_2680 VDD VDD PMOS l=6.000000000000001e-08 w=4.0000000000000003e-07
MN2685 inv_2683 inv_2680 0 0 NMOS l=6.000000000000001e-08 w=2.0000000000000002e-07
MP2687 inv_2686 Cin8_25 VDD VDD PMOS l=6.000000000000001e-08 w=4.0000000000000003e-07
MN2688 inv_2686 Cin8_25 0 0 NMOS l=6.000000000000001e-08 w=2.0000000000000002e-07
MP2690 inv_2689 xor_2334 VDD VDD PMOS l=6.000000000000001e-08 w=4.0000000000000003e-07
MN2691 inv_2689 xor_2334 0 0 NMOS l=6.000000000000001e-08 w=2.0000000000000002e-07
MN2693 Cin8_25 inv_2689 xor_2692 0 NMOS l=6.000000000000001e-08 w=2.0000000000000002e-07
MP2694 Cin8_25 xor_2334 xor_2692 VDD PMOS l=6.000000000000001e-08 w=4.0000000000000003e-07
MN2695 inv_2686 xor_2334 xor_2692 0 NMOS l=6.000000000000001e-08 w=2.0000000000000002e-07
MP2696 inv_2686 inv_2689 xor_2692 VDD PMOS l=6.000000000000001e-08 w=4.0000000000000003e-07
MP2698 inv_2697 xor_2692 VDD VDD PMOS l=6.000000000000001e-08 w=4.0000000000000003e-07
MN2699 inv_2697 xor_2692 0 0 NMOS l=6.000000000000001e-08 w=2.0000000000000002e-07
MP2701 inv_2700 inv_2683 VDD VDD PMOS l=6.000000000000001e-08 w=4.0000000000000003e-07
MN2702 inv_2700 inv_2683 0 0 NMOS l=6.000000000000001e-08 w=2.0000000000000002e-07
MN2704 xor_2692 inv_2700 xor_2703 0 NMOS l=6.000000000000001e-08 w=2.0000000000000002e-07
MP2705 xor_2692 inv_2683 xor_2703 VDD PMOS l=6.000000000000001e-08 w=4.0000000000000003e-07
MN2706 inv_2697 inv_2683 xor_2703 0 NMOS l=6.000000000000001e-08 w=2.0000000000000002e-07
MP2707 inv_2697 inv_2700 xor_2703 VDD PMOS l=6.000000000000001e-08 w=4.0000000000000003e-07
MN2709 inv_2683 xor_2692 cout_2708 0 NMOS l=6.000000000000001e-08 w=2.0000000000000002e-07
MP2710 inv_2683 inv_2697 cout_2708 VDD PMOS l=6.000000000000001e-08 w=4.0000000000000003e-07
MN2711 Cin8_25 inv_2697 cout_2708 0 NMOS l=6.000000000000001e-08 w=2.0000000000000002e-07
MP2712 Cin8_25 xor_2692 cout_2708 VDD PMOS l=6.000000000000001e-08 w=4.0000000000000003e-07
MP2714 inv_2713 cout_2708 VDD VDD PMOS l=6.000000000000001e-08 w=4.0000000000000003e-07
MN2715 inv_2713 cout_2708 0 0 NMOS l=6.000000000000001e-08 w=2.0000000000000002e-07
MP2717 inv_2716 inv_2713 VDD VDD PMOS l=6.000000000000001e-08 w=4.0000000000000003e-07
MN2718 inv_2716 inv_2713 0 0 NMOS l=6.000000000000001e-08 w=2.0000000000000002e-07
MP2720 inv_2719 Cin9_26 VDD VDD PMOS l=6.000000000000001e-08 w=4.0000000000000003e-07
MN2721 inv_2719 Cin9_26 0 0 NMOS l=6.000000000000001e-08 w=2.0000000000000002e-07
MP2723 inv_2722 xor_2345 VDD VDD PMOS l=6.000000000000001e-08 w=4.0000000000000003e-07
MN2724 inv_2722 xor_2345 0 0 NMOS l=6.000000000000001e-08 w=2.0000000000000002e-07
MN2726 Cin9_26 inv_2722 xor_2725 0 NMOS l=6.000000000000001e-08 w=2.0000000000000002e-07
MP2727 Cin9_26 xor_2345 xor_2725 VDD PMOS l=6.000000000000001e-08 w=4.0000000000000003e-07
MN2728 inv_2719 xor_2345 xor_2725 0 NMOS l=6.000000000000001e-08 w=2.0000000000000002e-07
MP2729 inv_2719 inv_2722 xor_2725 VDD PMOS l=6.000000000000001e-08 w=4.0000000000000003e-07
MP2731 inv_2730 xor_2725 VDD VDD PMOS l=6.000000000000001e-08 w=4.0000000000000003e-07
MN2732 inv_2730 xor_2725 0 0 NMOS l=6.000000000000001e-08 w=2.0000000000000002e-07
MP2734 inv_2733 inv_2716 VDD VDD PMOS l=6.000000000000001e-08 w=4.0000000000000003e-07
MN2735 inv_2733 inv_2716 0 0 NMOS l=6.000000000000001e-08 w=2.0000000000000002e-07
MN2737 xor_2725 inv_2733 xor_2736 0 NMOS l=6.000000000000001e-08 w=2.0000000000000002e-07
MP2738 xor_2725 inv_2716 xor_2736 VDD PMOS l=6.000000000000001e-08 w=4.0000000000000003e-07
MN2739 inv_2730 inv_2716 xor_2736 0 NMOS l=6.000000000000001e-08 w=2.0000000000000002e-07
MP2740 inv_2730 inv_2733 xor_2736 VDD PMOS l=6.000000000000001e-08 w=4.0000000000000003e-07
MN2742 inv_2716 xor_2725 cout_2741 0 NMOS l=6.000000000000001e-08 w=2.0000000000000002e-07
MP2743 inv_2716 inv_2730 cout_2741 VDD PMOS l=6.000000000000001e-08 w=4.0000000000000003e-07
MN2744 Cin9_26 inv_2730 cout_2741 0 NMOS l=6.000000000000001e-08 w=2.0000000000000002e-07
MP2745 Cin9_26 xor_2725 cout_2741 VDD PMOS l=6.000000000000001e-08 w=4.0000000000000003e-07
MP2747 inv_2746 cout_2741 VDD VDD PMOS l=6.000000000000001e-08 w=4.0000000000000003e-07
MN2748 inv_2746 cout_2741 0 0 NMOS l=6.000000000000001e-08 w=2.0000000000000002e-07
MP2750 inv_2749 inv_2746 VDD VDD PMOS l=6.000000000000001e-08 w=4.0000000000000003e-07
MN2751 inv_2749 inv_2746 0 0 NMOS l=6.000000000000001e-08 w=2.0000000000000002e-07
MP2753 inv_2752 Cin10_27 VDD VDD PMOS l=6.000000000000001e-08 w=4.0000000000000003e-07
MN2754 inv_2752 Cin10_27 0 0 NMOS l=6.000000000000001e-08 w=2.0000000000000002e-07
MP2756 inv_2755 xor_2356 VDD VDD PMOS l=6.000000000000001e-08 w=4.0000000000000003e-07
MN2757 inv_2755 xor_2356 0 0 NMOS l=6.000000000000001e-08 w=2.0000000000000002e-07
MN2759 Cin10_27 inv_2755 xor_2758 0 NMOS l=6.000000000000001e-08 w=2.0000000000000002e-07
MP2760 Cin10_27 xor_2356 xor_2758 VDD PMOS l=6.000000000000001e-08 w=4.0000000000000003e-07
MN2761 inv_2752 xor_2356 xor_2758 0 NMOS l=6.000000000000001e-08 w=2.0000000000000002e-07
MP2762 inv_2752 inv_2755 xor_2758 VDD PMOS l=6.000000000000001e-08 w=4.0000000000000003e-07
MP2764 inv_2763 xor_2758 VDD VDD PMOS l=6.000000000000001e-08 w=4.0000000000000003e-07
MN2765 inv_2763 xor_2758 0 0 NMOS l=6.000000000000001e-08 w=2.0000000000000002e-07
MP2767 inv_2766 inv_2749 VDD VDD PMOS l=6.000000000000001e-08 w=4.0000000000000003e-07
MN2768 inv_2766 inv_2749 0 0 NMOS l=6.000000000000001e-08 w=2.0000000000000002e-07
MN2770 xor_2758 inv_2766 xor_2769 0 NMOS l=6.000000000000001e-08 w=2.0000000000000002e-07
MP2771 xor_2758 inv_2749 xor_2769 VDD PMOS l=6.000000000000001e-08 w=4.0000000000000003e-07
MN2772 inv_2763 inv_2749 xor_2769 0 NMOS l=6.000000000000001e-08 w=2.0000000000000002e-07
MP2773 inv_2763 inv_2766 xor_2769 VDD PMOS l=6.000000000000001e-08 w=4.0000000000000003e-07
MN2775 inv_2749 xor_2758 cout_2774 0 NMOS l=6.000000000000001e-08 w=2.0000000000000002e-07
MP2776 inv_2749 inv_2763 cout_2774 VDD PMOS l=6.000000000000001e-08 w=4.0000000000000003e-07
MN2777 Cin10_27 inv_2763 cout_2774 0 NMOS l=6.000000000000001e-08 w=2.0000000000000002e-07
MP2778 Cin10_27 xor_2758 cout_2774 VDD PMOS l=6.000000000000001e-08 w=4.0000000000000003e-07
MP2780 inv_2779 cout_2774 VDD VDD PMOS l=6.000000000000001e-08 w=4.0000000000000003e-07
MN2781 inv_2779 cout_2774 0 0 NMOS l=6.000000000000001e-08 w=2.0000000000000002e-07
MP2783 inv_2782 inv_2779 VDD VDD PMOS l=6.000000000000001e-08 w=4.0000000000000003e-07
MN2784 inv_2782 inv_2779 0 0 NMOS l=6.000000000000001e-08 w=2.0000000000000002e-07
MP2786 inv_2785 Cin11_28 VDD VDD PMOS l=6.000000000000001e-08 w=4.0000000000000003e-07
MN2787 inv_2785 Cin11_28 0 0 NMOS l=6.000000000000001e-08 w=2.0000000000000002e-07
MP2789 inv_2788 xor_2367 VDD VDD PMOS l=6.000000000000001e-08 w=4.0000000000000003e-07
MN2790 inv_2788 xor_2367 0 0 NMOS l=6.000000000000001e-08 w=2.0000000000000002e-07
MN2792 Cin11_28 inv_2788 xor_2791 0 NMOS l=6.000000000000001e-08 w=2.0000000000000002e-07
MP2793 Cin11_28 xor_2367 xor_2791 VDD PMOS l=6.000000000000001e-08 w=4.0000000000000003e-07
MN2794 inv_2785 xor_2367 xor_2791 0 NMOS l=6.000000000000001e-08 w=2.0000000000000002e-07
MP2795 inv_2785 inv_2788 xor_2791 VDD PMOS l=6.000000000000001e-08 w=4.0000000000000003e-07
MP2797 inv_2796 xor_2791 VDD VDD PMOS l=6.000000000000001e-08 w=4.0000000000000003e-07
MN2798 inv_2796 xor_2791 0 0 NMOS l=6.000000000000001e-08 w=2.0000000000000002e-07
MP2800 inv_2799 inv_2782 VDD VDD PMOS l=6.000000000000001e-08 w=4.0000000000000003e-07
MN2801 inv_2799 inv_2782 0 0 NMOS l=6.000000000000001e-08 w=2.0000000000000002e-07
MN2803 xor_2791 inv_2799 xor_2802 0 NMOS l=6.000000000000001e-08 w=2.0000000000000002e-07
MP2804 xor_2791 inv_2782 xor_2802 VDD PMOS l=6.000000000000001e-08 w=4.0000000000000003e-07
MN2805 inv_2796 inv_2782 xor_2802 0 NMOS l=6.000000000000001e-08 w=2.0000000000000002e-07
MP2806 inv_2796 inv_2799 xor_2802 VDD PMOS l=6.000000000000001e-08 w=4.0000000000000003e-07
MN2808 inv_2782 xor_2791 cout_2807 0 NMOS l=6.000000000000001e-08 w=2.0000000000000002e-07
MP2809 inv_2782 inv_2796 cout_2807 VDD PMOS l=6.000000000000001e-08 w=4.0000000000000003e-07
MN2810 Cin11_28 inv_2796 cout_2807 0 NMOS l=6.000000000000001e-08 w=2.0000000000000002e-07
MP2811 Cin11_28 xor_2791 cout_2807 VDD PMOS l=6.000000000000001e-08 w=4.0000000000000003e-07
MP2813 inv_2812 cout_2807 VDD VDD PMOS l=6.000000000000001e-08 w=4.0000000000000003e-07
MN2814 inv_2812 cout_2807 0 0 NMOS l=6.000000000000001e-08 w=2.0000000000000002e-07
MP2816 inv_2815 inv_2812 VDD VDD PMOS l=6.000000000000001e-08 w=4.0000000000000003e-07
MN2817 inv_2815 inv_2812 0 0 NMOS l=6.000000000000001e-08 w=2.0000000000000002e-07
MP2819 inv_2818 Cin12_29 VDD VDD PMOS l=6.000000000000001e-08 w=4.0000000000000003e-07
MN2820 inv_2818 Cin12_29 0 0 NMOS l=6.000000000000001e-08 w=2.0000000000000002e-07
MP2822 inv_2821 xor_2378 VDD VDD PMOS l=6.000000000000001e-08 w=4.0000000000000003e-07
MN2823 inv_2821 xor_2378 0 0 NMOS l=6.000000000000001e-08 w=2.0000000000000002e-07
MN2825 Cin12_29 inv_2821 xor_2824 0 NMOS l=6.000000000000001e-08 w=2.0000000000000002e-07
MP2826 Cin12_29 xor_2378 xor_2824 VDD PMOS l=6.000000000000001e-08 w=4.0000000000000003e-07
MN2827 inv_2818 xor_2378 xor_2824 0 NMOS l=6.000000000000001e-08 w=2.0000000000000002e-07
MP2828 inv_2818 inv_2821 xor_2824 VDD PMOS l=6.000000000000001e-08 w=4.0000000000000003e-07
MP2830 inv_2829 xor_2824 VDD VDD PMOS l=6.000000000000001e-08 w=4.0000000000000003e-07
MN2831 inv_2829 xor_2824 0 0 NMOS l=6.000000000000001e-08 w=2.0000000000000002e-07
MP2833 inv_2832 inv_2815 VDD VDD PMOS l=6.000000000000001e-08 w=4.0000000000000003e-07
MN2834 inv_2832 inv_2815 0 0 NMOS l=6.000000000000001e-08 w=2.0000000000000002e-07
MN2836 xor_2824 inv_2832 xor_2835 0 NMOS l=6.000000000000001e-08 w=2.0000000000000002e-07
MP2837 xor_2824 inv_2815 xor_2835 VDD PMOS l=6.000000000000001e-08 w=4.0000000000000003e-07
MN2838 inv_2829 inv_2815 xor_2835 0 NMOS l=6.000000000000001e-08 w=2.0000000000000002e-07
MP2839 inv_2829 inv_2832 xor_2835 VDD PMOS l=6.000000000000001e-08 w=4.0000000000000003e-07
MN2841 inv_2815 xor_2824 cout_2840 0 NMOS l=6.000000000000001e-08 w=2.0000000000000002e-07
MP2842 inv_2815 inv_2829 cout_2840 VDD PMOS l=6.000000000000001e-08 w=4.0000000000000003e-07
MN2843 Cin12_29 inv_2829 cout_2840 0 NMOS l=6.000000000000001e-08 w=2.0000000000000002e-07
MP2844 Cin12_29 xor_2824 cout_2840 VDD PMOS l=6.000000000000001e-08 w=4.0000000000000003e-07
MP2846 inv_2845 cout_2840 VDD VDD PMOS l=6.000000000000001e-08 w=4.0000000000000003e-07
MN2847 inv_2845 cout_2840 0 0 NMOS l=6.000000000000001e-08 w=2.0000000000000002e-07
MP2849 inv_2848 inv_2845 VDD VDD PMOS l=6.000000000000001e-08 w=4.0000000000000003e-07
MN2850 inv_2848 inv_2845 0 0 NMOS l=6.000000000000001e-08 w=2.0000000000000002e-07
MP2852 inv_2851 Cin13_30 VDD VDD PMOS l=6.000000000000001e-08 w=4.0000000000000003e-07
MN2853 inv_2851 Cin13_30 0 0 NMOS l=6.000000000000001e-08 w=2.0000000000000002e-07
MP2855 inv_2854 xor_2389 VDD VDD PMOS l=6.000000000000001e-08 w=4.0000000000000003e-07
MN2856 inv_2854 xor_2389 0 0 NMOS l=6.000000000000001e-08 w=2.0000000000000002e-07
MN2858 Cin13_30 inv_2854 xor_2857 0 NMOS l=6.000000000000001e-08 w=2.0000000000000002e-07
MP2859 Cin13_30 xor_2389 xor_2857 VDD PMOS l=6.000000000000001e-08 w=4.0000000000000003e-07
MN2860 inv_2851 xor_2389 xor_2857 0 NMOS l=6.000000000000001e-08 w=2.0000000000000002e-07
MP2861 inv_2851 inv_2854 xor_2857 VDD PMOS l=6.000000000000001e-08 w=4.0000000000000003e-07
MP2863 inv_2862 xor_2857 VDD VDD PMOS l=6.000000000000001e-08 w=4.0000000000000003e-07
MN2864 inv_2862 xor_2857 0 0 NMOS l=6.000000000000001e-08 w=2.0000000000000002e-07
MP2866 inv_2865 inv_2848 VDD VDD PMOS l=6.000000000000001e-08 w=4.0000000000000003e-07
MN2867 inv_2865 inv_2848 0 0 NMOS l=6.000000000000001e-08 w=2.0000000000000002e-07
MN2869 xor_2857 inv_2865 xor_2868 0 NMOS l=6.000000000000001e-08 w=2.0000000000000002e-07
MP2870 xor_2857 inv_2848 xor_2868 VDD PMOS l=6.000000000000001e-08 w=4.0000000000000003e-07
MN2871 inv_2862 inv_2848 xor_2868 0 NMOS l=6.000000000000001e-08 w=2.0000000000000002e-07
MP2872 inv_2862 inv_2865 xor_2868 VDD PMOS l=6.000000000000001e-08 w=4.0000000000000003e-07
MN2874 inv_2848 xor_2857 cout_2873 0 NMOS l=6.000000000000001e-08 w=2.0000000000000002e-07
MP2875 inv_2848 inv_2862 cout_2873 VDD PMOS l=6.000000000000001e-08 w=4.0000000000000003e-07
MN2876 Cin13_30 inv_2862 cout_2873 0 NMOS l=6.000000000000001e-08 w=2.0000000000000002e-07
MP2877 Cin13_30 xor_2857 cout_2873 VDD PMOS l=6.000000000000001e-08 w=4.0000000000000003e-07
MP2879 inv_2878 cout_2873 VDD VDD PMOS l=6.000000000000001e-08 w=4.0000000000000003e-07
MN2880 inv_2878 cout_2873 0 0 NMOS l=6.000000000000001e-08 w=2.0000000000000002e-07
MP2882 inv_2881 inv_2878 VDD VDD PMOS l=6.000000000000001e-08 w=4.0000000000000003e-07
MN2883 inv_2881 inv_2878 0 0 NMOS l=6.000000000000001e-08 w=2.0000000000000002e-07
MP2885 inv_2884 Cin14_31 VDD VDD PMOS l=6.000000000000001e-08 w=4.0000000000000003e-07
MN2886 inv_2884 Cin14_31 0 0 NMOS l=6.000000000000001e-08 w=2.0000000000000002e-07
MP2888 inv_2887 xor_2400 VDD VDD PMOS l=6.000000000000001e-08 w=4.0000000000000003e-07
MN2889 inv_2887 xor_2400 0 0 NMOS l=6.000000000000001e-08 w=2.0000000000000002e-07
MN2891 Cin14_31 inv_2887 xor_2890 0 NMOS l=6.000000000000001e-08 w=2.0000000000000002e-07
MP2892 Cin14_31 xor_2400 xor_2890 VDD PMOS l=6.000000000000001e-08 w=4.0000000000000003e-07
MN2893 inv_2884 xor_2400 xor_2890 0 NMOS l=6.000000000000001e-08 w=2.0000000000000002e-07
MP2894 inv_2884 inv_2887 xor_2890 VDD PMOS l=6.000000000000001e-08 w=4.0000000000000003e-07
MP2896 inv_2895 xor_2890 VDD VDD PMOS l=6.000000000000001e-08 w=4.0000000000000003e-07
MN2897 inv_2895 xor_2890 0 0 NMOS l=6.000000000000001e-08 w=2.0000000000000002e-07
MP2899 inv_2898 inv_2881 VDD VDD PMOS l=6.000000000000001e-08 w=4.0000000000000003e-07
MN2900 inv_2898 inv_2881 0 0 NMOS l=6.000000000000001e-08 w=2.0000000000000002e-07
MN2902 xor_2890 inv_2898 xor_2901 0 NMOS l=6.000000000000001e-08 w=2.0000000000000002e-07
MP2903 xor_2890 inv_2881 xor_2901 VDD PMOS l=6.000000000000001e-08 w=4.0000000000000003e-07
MN2904 inv_2895 inv_2881 xor_2901 0 NMOS l=6.000000000000001e-08 w=2.0000000000000002e-07
MP2905 inv_2895 inv_2898 xor_2901 VDD PMOS l=6.000000000000001e-08 w=4.0000000000000003e-07
MN2907 inv_2881 xor_2890 cout_2906 0 NMOS l=6.000000000000001e-08 w=2.0000000000000002e-07
MP2908 inv_2881 inv_2895 cout_2906 VDD PMOS l=6.000000000000001e-08 w=4.0000000000000003e-07
MN2909 Cin14_31 inv_2895 cout_2906 0 NMOS l=6.000000000000001e-08 w=2.0000000000000002e-07
MP2910 Cin14_31 xor_2890 cout_2906 VDD PMOS l=6.000000000000001e-08 w=4.0000000000000003e-07
MP2912 inv_2911 cout_2906 VDD VDD PMOS l=6.000000000000001e-08 w=4.0000000000000003e-07
MN2913 inv_2911 cout_2906 0 0 NMOS l=6.000000000000001e-08 w=2.0000000000000002e-07
MP2915 inv_2914 inv_2911 VDD VDD PMOS l=6.000000000000001e-08 w=4.0000000000000003e-07
MN2916 inv_2914 inv_2911 0 0 NMOS l=6.000000000000001e-08 w=2.0000000000000002e-07
MP2918 inv_2917 Cin15_32 VDD VDD PMOS l=6.000000000000001e-08 w=4.0000000000000003e-07
MN2919 inv_2917 Cin15_32 0 0 NMOS l=6.000000000000001e-08 w=2.0000000000000002e-07
MP2921 inv_2920 xor_2411 VDD VDD PMOS l=6.000000000000001e-08 w=4.0000000000000003e-07
MN2922 inv_2920 xor_2411 0 0 NMOS l=6.000000000000001e-08 w=2.0000000000000002e-07
MN2924 Cin15_32 inv_2920 xor_2923 0 NMOS l=6.000000000000001e-08 w=2.0000000000000002e-07
MP2925 Cin15_32 xor_2411 xor_2923 VDD PMOS l=6.000000000000001e-08 w=4.0000000000000003e-07
MN2926 inv_2917 xor_2411 xor_2923 0 NMOS l=6.000000000000001e-08 w=2.0000000000000002e-07
MP2927 inv_2917 inv_2920 xor_2923 VDD PMOS l=6.000000000000001e-08 w=4.0000000000000003e-07
MP2929 inv_2928 xor_2923 VDD VDD PMOS l=6.000000000000001e-08 w=4.0000000000000003e-07
MN2930 inv_2928 xor_2923 0 0 NMOS l=6.000000000000001e-08 w=2.0000000000000002e-07
MP2932 inv_2931 inv_2914 VDD VDD PMOS l=6.000000000000001e-08 w=4.0000000000000003e-07
MN2933 inv_2931 inv_2914 0 0 NMOS l=6.000000000000001e-08 w=2.0000000000000002e-07
MN2935 xor_2923 inv_2931 xor_2934 0 NMOS l=6.000000000000001e-08 w=2.0000000000000002e-07
MP2936 xor_2923 inv_2914 xor_2934 VDD PMOS l=6.000000000000001e-08 w=4.0000000000000003e-07
MN2937 inv_2928 inv_2914 xor_2934 0 NMOS l=6.000000000000001e-08 w=2.0000000000000002e-07
MP2938 inv_2928 inv_2931 xor_2934 VDD PMOS l=6.000000000000001e-08 w=4.0000000000000003e-07
MN2940 inv_2914 xor_2923 cout_2939 0 NMOS l=6.000000000000001e-08 w=2.0000000000000002e-07
MP2941 inv_2914 inv_2928 cout_2939 VDD PMOS l=6.000000000000001e-08 w=4.0000000000000003e-07
MN2942 Cin15_32 inv_2928 cout_2939 0 NMOS l=6.000000000000001e-08 w=2.0000000000000002e-07
MP2943 Cin15_32 xor_2923 cout_2939 VDD PMOS l=6.000000000000001e-08 w=4.0000000000000003e-07
MP2945 inv_2944 cout_2939 VDD VDD PMOS l=6.000000000000001e-08 w=4.0000000000000003e-07
MN2946 inv_2944 cout_2939 0 0 NMOS l=6.000000000000001e-08 w=2.0000000000000002e-07
MP2948 inv_2947 inv_2944 VDD VDD PMOS l=6.000000000000001e-08 w=4.0000000000000003e-07
MN2949 inv_2947 inv_2944 0 0 NMOS l=6.000000000000001e-08 w=2.0000000000000002e-07
MP2951 inv_2950 Cin15_32 VDD VDD PMOS l=6.000000000000001e-08 w=4.0000000000000003e-07
MN2952 inv_2950 Cin15_32 0 0 NMOS l=6.000000000000001e-08 w=2.0000000000000002e-07
MP2954 inv_2953 xor_2411 VDD VDD PMOS l=6.000000000000001e-08 w=4.0000000000000003e-07
MN2955 inv_2953 xor_2411 0 0 NMOS l=6.000000000000001e-08 w=2.0000000000000002e-07
MN2957 Cin15_32 inv_2953 xor_2956 0 NMOS l=6.000000000000001e-08 w=2.0000000000000002e-07
MP2958 Cin15_32 xor_2411 xor_2956 VDD PMOS l=6.000000000000001e-08 w=4.0000000000000003e-07
MN2959 inv_2950 xor_2411 xor_2956 0 NMOS l=6.000000000000001e-08 w=2.0000000000000002e-07
MP2960 inv_2950 inv_2953 xor_2956 VDD PMOS l=6.000000000000001e-08 w=4.0000000000000003e-07
MP2962 inv_2961 xor_2956 VDD VDD PMOS l=6.000000000000001e-08 w=4.0000000000000003e-07
MN2963 inv_2961 xor_2956 0 0 NMOS l=6.000000000000001e-08 w=2.0000000000000002e-07
MP2965 inv_2964 inv_2947 VDD VDD PMOS l=6.000000000000001e-08 w=4.0000000000000003e-07
MN2966 inv_2964 inv_2947 0 0 NMOS l=6.000000000000001e-08 w=2.0000000000000002e-07
MN2968 xor_2956 inv_2964 xor_2967 0 NMOS l=6.000000000000001e-08 w=2.0000000000000002e-07
MP2969 xor_2956 inv_2947 xor_2967 VDD PMOS l=6.000000000000001e-08 w=4.0000000000000003e-07
MN2970 inv_2961 inv_2947 xor_2967 0 NMOS l=6.000000000000001e-08 w=2.0000000000000002e-07
MP2971 inv_2961 inv_2964 xor_2967 VDD PMOS l=6.000000000000001e-08 w=4.0000000000000003e-07
MN2973 inv_2947 xor_2956 cout_2972 0 NMOS l=6.000000000000001e-08 w=2.0000000000000002e-07
MP2974 inv_2947 inv_2961 cout_2972 VDD PMOS l=6.000000000000001e-08 w=4.0000000000000003e-07
MN2975 Cin15_32 inv_2961 cout_2972 0 NMOS l=6.000000000000001e-08 w=2.0000000000000002e-07
MP2976 Cin15_32 xor_2956 cout_2972 VDD PMOS l=6.000000000000001e-08 w=4.0000000000000003e-07
MP2978 inv_2977 cout_2972 VDD VDD PMOS l=6.000000000000001e-08 w=4.0000000000000003e-07
MN2979 inv_2977 cout_2972 0 0 NMOS l=6.000000000000001e-08 w=2.0000000000000002e-07
MP2981 inv_2980 inv_2977 VDD VDD PMOS l=6.000000000000001e-08 w=4.0000000000000003e-07
MN2982 inv_2980 inv_2977 0 0 NMOS l=6.000000000000001e-08 w=2.0000000000000002e-07
MP2984 inv_2983 xor_2967 VDD VDD PMOS l=6.000000000000001e-08 w=4.0000000000000003e-07
MN2985 inv_2983 xor_2967 0 0 NMOS l=6.000000000000001e-08 w=2.0000000000000002e-07
MP2987 nand_2986 inv_2983 VDD VDD PMOS l=6.000000000000001e-08 w=4.0000000000000003e-07
MP2988 nand_2986 xor_2934 VDD VDD PMOS l=6.000000000000001e-08 w=4.0000000000000003e-07
MN2990 nand_2986 inv_2983 nd_2989 0 NMOS l=6.000000000000001e-08 w=2.0000000000000002e-07
MN2991 nd_2989 xor_2934 0 0 NMOS l=6.000000000000001e-08 w=2.0000000000000002e-07
MP2993 inv_2992 nand_2986 VDD VDD PMOS l=6.000000000000001e-08 w=4.0000000000000003e-07
MN2994 inv_2992 nand_2986 0 0 NMOS l=6.000000000000001e-08 w=2.0000000000000002e-07
MP2996 inv_2995 xor_2934 VDD VDD PMOS l=6.000000000000001e-08 w=4.0000000000000003e-07
MN2997 inv_2995 xor_2934 0 0 NMOS l=6.000000000000001e-08 w=2.0000000000000002e-07
MP2999 nand_2998 xor_2967 VDD VDD PMOS l=6.000000000000001e-08 w=4.0000000000000003e-07
MP3000 nand_2998 inv_2995 VDD VDD PMOS l=6.000000000000001e-08 w=4.0000000000000003e-07
MN3002 nand_2998 xor_2967 nd_3001 0 NMOS l=6.000000000000001e-08 w=2.0000000000000002e-07
MN3003 nd_3001 inv_2995 0 0 NMOS l=6.000000000000001e-08 w=2.0000000000000002e-07
MP3005 inv_3004 nand_2998 VDD VDD PMOS l=6.000000000000001e-08 w=4.0000000000000003e-07
MN3006 inv_3004 nand_2998 0 0 NMOS l=6.000000000000001e-08 w=2.0000000000000002e-07
MP3009 nor_3007 inv_2992 nu_3008 VDD PMOS l=6.000000000000001e-08 w=4.0000000000000003e-07
MP3010 nu_3008 inv_3004 VDD VDD PMOS l=6.000000000000001e-08 w=4.0000000000000003e-07
MN3011 nor_3007 inv_2992 0 0 NMOS l=6.000000000000001e-08 w=2.0000000000000002e-07
MN3012 nor_3007 inv_3004 0 0 NMOS l=6.000000000000001e-08 w=2.0000000000000002e-07
MP3014 inv_3013 nor_3007 VDD VDD PMOS l=6.000000000000001e-08 w=4.0000000000000003e-07
MN3015 inv_3013 nor_3007 0 0 NMOS l=6.000000000000001e-08 w=2.0000000000000002e-07
MP3017 inv_3016 inv_3013 VDD VDD PMOS l=6.000000000000001e-08 w=4.0000000000000003e-07
MN3018 inv_3016 inv_3013 0 0 NMOS l=6.000000000000001e-08 w=2.0000000000000002e-07
MN3020 xor_2439 inv_3016 mux_3019 0 NMOS l=6.000000000000001e-08 w=2.0000000000000002e-07
MP3021 xor_2439 inv_3013 mux_3019 VDD PMOS l=6.000000000000001e-08 w=4.0000000000000003e-07
MN3022 inv_2992 inv_3013 mux_3019 0 NMOS l=6.000000000000001e-08 w=2.0000000000000002e-07
MP3023 inv_2992 inv_3016 mux_3019 VDD PMOS l=6.000000000000001e-08 w=4.0000000000000003e-07
MN3025 xor_2472 inv_3016 mux_3024 0 NMOS l=6.000000000000001e-08 w=2.0000000000000002e-07
MP3026 xor_2472 inv_3013 mux_3024 VDD PMOS l=6.000000000000001e-08 w=4.0000000000000003e-07
MN3027 inv_2992 inv_3013 mux_3024 0 NMOS l=6.000000000000001e-08 w=2.0000000000000002e-07
MP3028 inv_2992 inv_3016 mux_3024 VDD PMOS l=6.000000000000001e-08 w=4.0000000000000003e-07
MN3030 xor_2505 inv_3016 mux_3029 0 NMOS l=6.000000000000001e-08 w=2.0000000000000002e-07
MP3031 xor_2505 inv_3013 mux_3029 VDD PMOS l=6.000000000000001e-08 w=4.0000000000000003e-07
MN3032 inv_2992 inv_3013 mux_3029 0 NMOS l=6.000000000000001e-08 w=2.0000000000000002e-07
MP3033 inv_2992 inv_3016 mux_3029 VDD PMOS l=6.000000000000001e-08 w=4.0000000000000003e-07
MN3035 xor_2538 inv_3016 mux_3034 0 NMOS l=6.000000000000001e-08 w=2.0000000000000002e-07
MP3036 xor_2538 inv_3013 mux_3034 VDD PMOS l=6.000000000000001e-08 w=4.0000000000000003e-07
MN3037 inv_2992 inv_3013 mux_3034 0 NMOS l=6.000000000000001e-08 w=2.0000000000000002e-07
MP3038 inv_2992 inv_3016 mux_3034 VDD PMOS l=6.000000000000001e-08 w=4.0000000000000003e-07
MN3040 xor_2571 inv_3016 mux_3039 0 NMOS l=6.000000000000001e-08 w=2.0000000000000002e-07
MP3041 xor_2571 inv_3013 mux_3039 VDD PMOS l=6.000000000000001e-08 w=4.0000000000000003e-07
MN3042 inv_2992 inv_3013 mux_3039 0 NMOS l=6.000000000000001e-08 w=2.0000000000000002e-07
MP3043 inv_2992 inv_3016 mux_3039 VDD PMOS l=6.000000000000001e-08 w=4.0000000000000003e-07
MN3045 xor_2604 inv_3016 mux_3044 0 NMOS l=6.000000000000001e-08 w=2.0000000000000002e-07
MP3046 xor_2604 inv_3013 mux_3044 VDD PMOS l=6.000000000000001e-08 w=4.0000000000000003e-07
MN3047 inv_2992 inv_3013 mux_3044 0 NMOS l=6.000000000000001e-08 w=2.0000000000000002e-07
MP3048 inv_2992 inv_3016 mux_3044 VDD PMOS l=6.000000000000001e-08 w=4.0000000000000003e-07
MN3050 xor_2637 inv_3016 mux_3049 0 NMOS l=6.000000000000001e-08 w=2.0000000000000002e-07
MP3051 xor_2637 inv_3013 mux_3049 VDD PMOS l=6.000000000000001e-08 w=4.0000000000000003e-07
MN3052 inv_2992 inv_3013 mux_3049 0 NMOS l=6.000000000000001e-08 w=2.0000000000000002e-07
MP3053 inv_2992 inv_3016 mux_3049 VDD PMOS l=6.000000000000001e-08 w=4.0000000000000003e-07
MN3055 xor_2670 inv_3016 mux_3054 0 NMOS l=6.000000000000001e-08 w=2.0000000000000002e-07
MP3056 xor_2670 inv_3013 mux_3054 VDD PMOS l=6.000000000000001e-08 w=4.0000000000000003e-07
MN3057 inv_2992 inv_3013 mux_3054 0 NMOS l=6.000000000000001e-08 w=2.0000000000000002e-07
MP3058 inv_2992 inv_3016 mux_3054 VDD PMOS l=6.000000000000001e-08 w=4.0000000000000003e-07
MN3060 xor_2703 inv_3016 mux_3059 0 NMOS l=6.000000000000001e-08 w=2.0000000000000002e-07
MP3061 xor_2703 inv_3013 mux_3059 VDD PMOS l=6.000000000000001e-08 w=4.0000000000000003e-07
MN3062 inv_2992 inv_3013 mux_3059 0 NMOS l=6.000000000000001e-08 w=2.0000000000000002e-07
MP3063 inv_2992 inv_3016 mux_3059 VDD PMOS l=6.000000000000001e-08 w=4.0000000000000003e-07
MN3065 xor_2736 inv_3016 mux_3064 0 NMOS l=6.000000000000001e-08 w=2.0000000000000002e-07
MP3066 xor_2736 inv_3013 mux_3064 VDD PMOS l=6.000000000000001e-08 w=4.0000000000000003e-07
MN3067 inv_2992 inv_3013 mux_3064 0 NMOS l=6.000000000000001e-08 w=2.0000000000000002e-07
MP3068 inv_2992 inv_3016 mux_3064 VDD PMOS l=6.000000000000001e-08 w=4.0000000000000003e-07
MN3070 xor_2769 inv_3016 mux_3069 0 NMOS l=6.000000000000001e-08 w=2.0000000000000002e-07
MP3071 xor_2769 inv_3013 mux_3069 VDD PMOS l=6.000000000000001e-08 w=4.0000000000000003e-07
MN3072 inv_2992 inv_3013 mux_3069 0 NMOS l=6.000000000000001e-08 w=2.0000000000000002e-07
MP3073 inv_2992 inv_3016 mux_3069 VDD PMOS l=6.000000000000001e-08 w=4.0000000000000003e-07
MN3075 xor_2802 inv_3016 mux_3074 0 NMOS l=6.000000000000001e-08 w=2.0000000000000002e-07
MP3076 xor_2802 inv_3013 mux_3074 VDD PMOS l=6.000000000000001e-08 w=4.0000000000000003e-07
MN3077 inv_2992 inv_3013 mux_3074 0 NMOS l=6.000000000000001e-08 w=2.0000000000000002e-07
MP3078 inv_2992 inv_3016 mux_3074 VDD PMOS l=6.000000000000001e-08 w=4.0000000000000003e-07
MN3080 xor_2835 inv_3016 mux_3079 0 NMOS l=6.000000000000001e-08 w=2.0000000000000002e-07
MP3081 xor_2835 inv_3013 mux_3079 VDD PMOS l=6.000000000000001e-08 w=4.0000000000000003e-07
MN3082 inv_2992 inv_3013 mux_3079 0 NMOS l=6.000000000000001e-08 w=2.0000000000000002e-07
MP3083 inv_2992 inv_3016 mux_3079 VDD PMOS l=6.000000000000001e-08 w=4.0000000000000003e-07
MN3085 xor_2868 inv_3016 mux_3084 0 NMOS l=6.000000000000001e-08 w=2.0000000000000002e-07
MP3086 xor_2868 inv_3013 mux_3084 VDD PMOS l=6.000000000000001e-08 w=4.0000000000000003e-07
MN3087 inv_2992 inv_3013 mux_3084 0 NMOS l=6.000000000000001e-08 w=2.0000000000000002e-07
MP3088 inv_2992 inv_3016 mux_3084 VDD PMOS l=6.000000000000001e-08 w=4.0000000000000003e-07
MN3090 xor_2901 inv_3016 mux_3089 0 NMOS l=6.000000000000001e-08 w=2.0000000000000002e-07
MP3091 xor_2901 inv_3013 mux_3089 VDD PMOS l=6.000000000000001e-08 w=4.0000000000000003e-07
MN3092 inv_2992 inv_3013 mux_3089 0 NMOS l=6.000000000000001e-08 w=2.0000000000000002e-07
MP3093 inv_2992 inv_3016 mux_3089 VDD PMOS l=6.000000000000001e-08 w=4.0000000000000003e-07
